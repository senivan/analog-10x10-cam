.title Global shutter discrete camera
.subckt pixel pd vr rst refgate siggate sel br bs ci=100p ch=1n rl=1e12 dark=2p vos=100u

Dphoto 0 pd silicon
Cjunction pd 0 4p
Cintegration pd 0 {ci}
Rintegration pd 0 10T
Idark pd 0 {dark}
Ibias pd 0 0.2p
Sreset pd vr rst 0 gate
Bfollower buf 0 V=max(0.02,min(v(vdd)-0.02,v(pd)+vos))
Rout buf drive 50

Shr drive hr refgate 0 gate
Chr hr 0 {ch}
Rhr hr 0 {rl}
Ihr hr 0 0.2p
Ehr sourcehr 0 hr 0 1
Routhr sourcehr pinhr 50
Sreadhr pinhr br sel 0 gate

Shs drive hs siggate 0 gate
Chs hs 0 {ch}
Rhs hs 0 {rl}
Ihs hs 0 0.2p
Ehs sourcehs 0 hs 0 1
Rouths sourcehs pinhs 50
Sreadhs pinhs bs sel 0 gate

.ends pixel

.subckt amp plus minus out

* Dominant pole, 4 MHz GBW, 100k DC gain, 4 V/us slew, rail clamps
Bgm 0 pole I=max(-400u,min(400u,2.513m*(v(plus,minus)+20u)))
Rp pole 0 39.79meg
Cp pole 0 100p
Brails pole 0 I=(min(0,v(pole)-0.02)+max(0,v(pole)-v(vdd)+0.02))/2
Ebuf drive 0 pole 0 1
Rout drive out 10

.ends amp
Vdd vdd 0 5.0
Vr vr 0 3.0
Vrst rst 0 PWL(0 3.3 2.5e-05 3.3 2.502e-05 0)
Vrg rg 0 PWL(0 0 5e-06 0 5.02e-06 3.3 2.4e-05 3.3 2.402e-05 0)
Vsg sg 0 PWL(0 0 0.010017 0 0.01001702 3.3 0.010025 3.3 0.01002502 0)
Iphoto0 pd0 0 1.4165705640334636e-10
Vsel0 sel0 0 PWL(0 0 0.01003 0 0.01003002 3.3 0.0100699 3.3 0.01006992 0)
X0 pd0 vr rst rg sg sel0 br bs pixel ch=1e-09 ci=1e-10 dark=2e-12 rl=1000000000000.0
Iphoto1 pd1 0 1.4165705640334636e-10
Vsel1 sel1 0 PWL(0 0 0.01007 0 0.01007002 3.3 0.0101099 3.3 0.01010992 0)
X1 pd1 vr rst rg sg sel1 br bs pixel ch=1e-09 ci=1e-10 dark=2e-12 rl=1000000000000.0
Iphoto2 pd2 0 1.4165705640334636e-10
Vsel2 sel2 0 PWL(0 0 0.01011 0 0.01011002 3.3 0.0101499 3.3 0.01014992 0)
X2 pd2 vr rst rg sg sel2 br bs pixel ch=1e-09 ci=1e-10 dark=2e-12 rl=1000000000000.0
Iphoto3 pd3 0 1.4165705640334636e-10
Vsel3 sel3 0 PWL(0 0 0.01015 0 0.01015002 3.3 0.0101899 3.3 0.01018992 0)
X3 pd3 vr rst rg sg sel3 br bs pixel ch=1e-09 ci=1e-10 dark=2e-12 rl=1000000000000.0
Iphoto4 pd4 0 1.4165705640334636e-10
Vsel4 sel4 0 PWL(0 0 0.01019 0 0.01019002 3.3 0.0102299 3.3 0.01022992 0)
X4 pd4 vr rst rg sg sel4 br bs pixel ch=1e-09 ci=1e-10 dark=2e-12 rl=1000000000000.0
Iphoto5 pd5 0 1.4165705640334636e-10
Vsel5 sel5 0 PWL(0 0 0.01023 0 0.01023002 3.3 0.0102699 3.3 0.01026992 0)
X5 pd5 vr rst rg sg sel5 br bs pixel ch=1e-09 ci=1e-10 dark=2e-12 rl=1000000000000.0
Iphoto6 pd6 0 1.4165705640334636e-10
Vsel6 sel6 0 PWL(0 0 0.01027 0 0.01027002 3.3 0.0103099 3.3 0.01030992 0)
X6 pd6 vr rst rg sg sel6 br bs pixel ch=1e-09 ci=1e-10 dark=2e-12 rl=1000000000000.0
Iphoto7 pd7 0 1.4165705640334636e-10
Vsel7 sel7 0 PWL(0 0 0.01031 0 0.01031002 3.3 0.0103499 3.3 0.01034992 0)
X7 pd7 vr rst rg sg sel7 br bs pixel ch=1e-09 ci=1e-10 dark=2e-12 rl=1000000000000.0
Iphoto8 pd8 0 1.4165705640334636e-10
Vsel8 sel8 0 PWL(0 0 0.01035 0 0.01035002 3.3 0.0103899 3.3 0.01038992 0)
X8 pd8 vr rst rg sg sel8 br bs pixel ch=1e-09 ci=1e-10 dark=2e-12 rl=1000000000000.0
Iphoto9 pd9 0 1.4165705640334636e-10
Vsel9 sel9 0 PWL(0 0 0.01039 0 0.01039002 3.3 0.0104299 3.3 0.01042992 0)
X9 pd9 vr rst rg sg sel9 br bs pixel ch=1e-09 ci=1e-10 dark=2e-12 rl=1000000000000.0
Iphoto10 pd10 0 1.4165705640334636e-10
Vsel10 sel10 0 PWL(0 0 0.01043 0 0.01043002 3.3 0.0104699 3.3 0.01046992 0)
X10 pd10 vr rst rg sg sel10 br bs pixel ch=1e-09 ci=1e-10 dark=2e-12 rl=1000000000000.0
Iphoto11 pd11 0 8.082720190286637e-09
Vsel11 sel11 0 PWL(0 0 0.01047 0 0.01047002 3.3 0.0105099 3.3 0.01050992 0)
X11 pd11 vr rst rg sg sel11 br bs pixel ch=1e-09 ci=1e-10 dark=2e-12 rl=1000000000000.0
Iphoto12 pd12 0 8.082720190286637e-09
Vsel12 sel12 0 PWL(0 0 0.01051 0 0.01051002 3.3 0.0105499 3.3 0.01054992 0)
X12 pd12 vr rst rg sg sel12 br bs pixel ch=1e-09 ci=1e-10 dark=2e-12 rl=1000000000000.0
Iphoto13 pd13 0 8.082720190286637e-09
Vsel13 sel13 0 PWL(0 0 0.01055 0 0.01055002 3.3 0.0105899 3.3 0.01058992 0)
X13 pd13 vr rst rg sg sel13 br bs pixel ch=1e-09 ci=1e-10 dark=2e-12 rl=1000000000000.0
Iphoto14 pd14 0 9.357633311301471e-10
Vsel14 sel14 0 PWL(0 0 0.01059 0 0.01059002 3.3 0.0106299 3.3 0.01062992 0)
X14 pd14 vr rst rg sg sel14 br bs pixel ch=1e-09 ci=1e-10 dark=2e-12 rl=1000000000000.0
Iphoto15 pd15 0 1.1187717681750655e-09
Vsel15 sel15 0 PWL(0 0 0.01063 0 0.01063002 3.3 0.0106699 3.3 0.01066992 0)
X15 pd15 vr rst rg sg sel15 br bs pixel ch=1e-09 ci=1e-10 dark=2e-12 rl=1000000000000.0
Iphoto16 pd16 0 3.1055715680122377e-09
Vsel16 sel16 0 PWL(0 0 0.01067 0 0.01067002 3.3 0.0107099 3.3 0.01070992 0)
X16 pd16 vr rst rg sg sel16 br bs pixel ch=1e-09 ci=1e-10 dark=2e-12 rl=1000000000000.0
Iphoto17 pd17 0 3.1055715680122377e-09
Vsel17 sel17 0 PWL(0 0 0.01071 0 0.01071002 3.3 0.0107499 3.3 0.01074992 0)
X17 pd17 vr rst rg sg sel17 br bs pixel ch=1e-09 ci=1e-10 dark=2e-12 rl=1000000000000.0
Iphoto18 pd18 0 1.1187717681750655e-09
Vsel18 sel18 0 PWL(0 0 0.01075 0 0.01075002 3.3 0.0107899 3.3 0.01078992 0)
X18 pd18 vr rst rg sg sel18 br bs pixel ch=1e-09 ci=1e-10 dark=2e-12 rl=1000000000000.0
Iphoto19 pd19 0 1.4165705640334636e-10
Vsel19 sel19 0 PWL(0 0 0.01079 0 0.01079002 3.3 0.0108299 3.3 0.01082992 0)
X19 pd19 vr rst rg sg sel19 br bs pixel ch=1e-09 ci=1e-10 dark=2e-12 rl=1000000000000.0
Iphoto20 pd20 0 1.4165705640334636e-10
Vsel20 sel20 0 PWL(0 0 0.01083 0 0.01083002 3.3 0.0108699 3.3 0.01086992 0)
X20 pd20 vr rst rg sg sel20 br bs pixel ch=1e-09 ci=1e-10 dark=2e-12 rl=1000000000000.0
Iphoto21 pd21 0 1.6023782730102542e-08
Vsel21 sel21 0 PWL(0 0 0.01087 0 0.01087002 3.3 0.0109099 3.3 0.01090992 0)
X21 pd21 vr rst rg sg sel21 br bs pixel ch=1e-09 ci=1e-10 dark=2e-12 rl=1000000000000.0
Iphoto22 pd22 0 1.6023782730102542e-08
Vsel22 sel22 0 PWL(0 0 0.01091 0 0.01091002 3.3 0.0109499 3.3 0.01094992 0)
X22 pd22 vr rst rg sg sel22 br bs pixel ch=1e-09 ci=1e-10 dark=2e-12 rl=1000000000000.0
Iphoto23 pd23 0 1.6023782730102542e-08
Vsel23 sel23 0 PWL(0 0 0.01095 0 0.01095002 3.3 0.0109899 3.3 0.01098992 0)
X23 pd23 vr rst rg sg sel23 br bs pixel ch=1e-09 ci=1e-10 dark=2e-12 rl=1000000000000.0
Iphoto24 pd24 0 1.7298696152865887e-09
Vsel24 sel24 0 PWL(0 0 0.01099 0 0.01099002 3.3 0.0110299 3.3 0.01102992 0)
X24 pd24 vr rst rg sg sel24 br bs pixel ch=1e-09 ci=1e-10 dark=2e-12 rl=1000000000000.0
Iphoto25 pd25 0 3.1055715680122377e-09
Vsel25 sel25 0 PWL(0 0 0.01103 0 0.01103002 3.3 0.0110699 3.3 0.01106992 0)
X25 pd25 vr rst rg sg sel25 br bs pixel ch=1e-09 ci=1e-10 dark=2e-12 rl=1000000000000.0
Iphoto26 pd26 0 3.3987060673534867e-09
Vsel26 sel26 0 PWL(0 0 0.01107 0 0.01107002 3.3 0.0111099 3.3 0.01110992 0)
X26 pd26 vr rst rg sg sel26 br bs pixel ch=1e-09 ci=1e-10 dark=2e-12 rl=1000000000000.0
Iphoto27 pd27 0 3.3987060673534867e-09
Vsel27 sel27 0 PWL(0 0 0.01111 0 0.01111002 3.3 0.0111499 3.3 0.01114992 0)
X27 pd27 vr rst rg sg sel27 br bs pixel ch=1e-09 ci=1e-10 dark=2e-12 rl=1000000000000.0
Iphoto28 pd28 0 3.1055715680122377e-09
Vsel28 sel28 0 PWL(0 0 0.01115 0 0.01115002 3.3 0.0111899 3.3 0.01118992 0)
X28 pd28 vr rst rg sg sel28 br bs pixel ch=1e-09 ci=1e-10 dark=2e-12 rl=1000000000000.0
Iphoto29 pd29 0 1.4165705640334636e-10
Vsel29 sel29 0 PWL(0 0 0.01119 0 0.01119002 3.3 0.0112299 3.3 0.01122992 0)
X29 pd29 vr rst rg sg sel29 br bs pixel ch=1e-09 ci=1e-10 dark=2e-12 rl=1000000000000.0
Iphoto30 pd30 0 1.4165705640334636e-10
Vsel30 sel30 0 PWL(0 0 0.01123 0 0.01123002 3.3 0.0112699 3.3 0.01126992 0)
X30 pd30 vr rst rg sg sel30 br bs pixel ch=1e-09 ci=1e-10 dark=2e-12 rl=1000000000000.0
Iphoto31 pd31 0 1.6023782730102542e-08
Vsel31 sel31 0 PWL(0 0 0.01127 0 0.01127002 3.3 0.0113099 3.3 0.01130992 0)
X31 pd31 vr rst rg sg sel31 br bs pixel ch=1e-09 ci=1e-10 dark=2e-12 rl=1000000000000.0
Iphoto32 pd32 0 1.6023782730102542e-08
Vsel32 sel32 0 PWL(0 0 0.01131 0 0.01131002 3.3 0.0113499 3.3 0.01134992 0)
X32 pd32 vr rst rg sg sel32 br bs pixel ch=1e-09 ci=1e-10 dark=2e-12 rl=1000000000000.0
Iphoto33 pd33 0 1.6023782730102542e-08
Vsel33 sel33 0 PWL(0 0 0.01135 0 0.01135002 3.3 0.0113899 3.3 0.01138992 0)
X33 pd33 vr rst rg sg sel33 br bs pixel ch=1e-09 ci=1e-10 dark=2e-12 rl=1000000000000.0
Iphoto34 pd34 0 1.7298696152865887e-09
Vsel34 sel34 0 PWL(0 0 0.01139 0 0.01139002 3.3 0.0114299 3.3 0.01142992 0)
X34 pd34 vr rst rg sg sel34 br bs pixel ch=1e-09 ci=1e-10 dark=2e-12 rl=1000000000000.0
Iphoto35 pd35 0 3.1055715680122377e-09
Vsel35 sel35 0 PWL(0 0 0.01143 0 0.01143002 3.3 0.0114699 3.3 0.01146992 0)
X35 pd35 vr rst rg sg sel35 br bs pixel ch=1e-09 ci=1e-10 dark=2e-12 rl=1000000000000.0
Iphoto36 pd36 0 3.3987060673534867e-09
Vsel36 sel36 0 PWL(0 0 0.01147 0 0.01147002 3.3 0.0115099 3.3 0.01150992 0)
X36 pd36 vr rst rg sg sel36 br bs pixel ch=1e-09 ci=1e-10 dark=2e-12 rl=1000000000000.0
Iphoto37 pd37 0 3.3987060673534867e-09
Vsel37 sel37 0 PWL(0 0 0.01151 0 0.01151002 3.3 0.0115499 3.3 0.01154992 0)
X37 pd37 vr rst rg sg sel37 br bs pixel ch=1e-09 ci=1e-10 dark=2e-12 rl=1000000000000.0
Iphoto38 pd38 0 3.1055715680122377e-09
Vsel38 sel38 0 PWL(0 0 0.01155 0 0.01155002 3.3 0.0115899 3.3 0.01158992 0)
X38 pd38 vr rst rg sg sel38 br bs pixel ch=1e-09 ci=1e-10 dark=2e-12 rl=1000000000000.0
Iphoto39 pd39 0 1.4165705640334636e-10
Vsel39 sel39 0 PWL(0 0 0.01159 0 0.01159002 3.3 0.0116299 3.3 0.01162992 0)
X39 pd39 vr rst rg sg sel39 br bs pixel ch=1e-09 ci=1e-10 dark=2e-12 rl=1000000000000.0
Iphoto40 pd40 0 1.4165705640334636e-10
Vsel40 sel40 0 PWL(0 0 0.01163 0 0.01163002 3.3 0.0116699 3.3 0.01166992 0)
X40 pd40 vr rst rg sg sel40 br bs pixel ch=1e-09 ci=1e-10 dark=2e-12 rl=1000000000000.0
Iphoto41 pd41 0 1.6023782730102542e-08
Vsel41 sel41 0 PWL(0 0 0.01167 0 0.01167002 3.3 0.0117099 3.3 0.01170992 0)
X41 pd41 vr rst rg sg sel41 br bs pixel ch=1e-09 ci=1e-10 dark=2e-12 rl=1000000000000.0
Iphoto42 pd42 0 1.6023782730102542e-08
Vsel42 sel42 0 PWL(0 0 0.01171 0 0.01171002 3.3 0.0117499 3.3 0.01174992 0)
X42 pd42 vr rst rg sg sel42 br bs pixel ch=1e-09 ci=1e-10 dark=2e-12 rl=1000000000000.0
Iphoto43 pd43 0 1.6023782730102542e-08
Vsel43 sel43 0 PWL(0 0 0.01175 0 0.01175002 3.3 0.0117899 3.3 0.01178992 0)
X43 pd43 vr rst rg sg sel43 br bs pixel ch=1e-09 ci=1e-10 dark=2e-12 rl=1000000000000.0
Iphoto44 pd44 0 1.7298696152865887e-09
Vsel44 sel44 0 PWL(0 0 0.01179 0 0.01179002 3.3 0.0118299 3.3 0.01182992 0)
X44 pd44 vr rst rg sg sel44 br bs pixel ch=1e-09 ci=1e-10 dark=2e-12 rl=1000000000000.0
Iphoto45 pd45 0 1.1187717681750655e-09
Vsel45 sel45 0 PWL(0 0 0.01183 0 0.01183002 3.3 0.0118699 3.3 0.01186992 0)
X45 pd45 vr rst rg sg sel45 br bs pixel ch=1e-09 ci=1e-10 dark=2e-12 rl=1000000000000.0
Iphoto46 pd46 0 3.1055715680122377e-09
Vsel46 sel46 0 PWL(0 0 0.01187 0 0.01187002 3.3 0.0119099 3.3 0.01190992 0)
X46 pd46 vr rst rg sg sel46 br bs pixel ch=1e-09 ci=1e-10 dark=2e-12 rl=1000000000000.0
Iphoto47 pd47 0 3.1055715680122377e-09
Vsel47 sel47 0 PWL(0 0 0.01191 0 0.01191002 3.3 0.0119499 3.3 0.01194992 0)
X47 pd47 vr rst rg sg sel47 br bs pixel ch=1e-09 ci=1e-10 dark=2e-12 rl=1000000000000.0
Iphoto48 pd48 0 1.1187717681750655e-09
Vsel48 sel48 0 PWL(0 0 0.01195 0 0.01195002 3.3 0.0119899 3.3 0.01198992 0)
X48 pd48 vr rst rg sg sel48 br bs pixel ch=1e-09 ci=1e-10 dark=2e-12 rl=1000000000000.0
Iphoto49 pd49 0 1.4165705640334636e-10
Vsel49 sel49 0 PWL(0 0 0.01199 0 0.01199002 3.3 0.0120299 3.3 0.01202992 0)
X49 pd49 vr rst rg sg sel49 br bs pixel ch=1e-09 ci=1e-10 dark=2e-12 rl=1000000000000.0
Iphoto50 pd50 0 1.4165705640334636e-10
Vsel50 sel50 0 PWL(0 0 0.01203 0 0.01203002 3.3 0.0120699 3.3 0.01206992 0)
X50 pd50 vr rst rg sg sel50 br bs pixel ch=1e-09 ci=1e-10 dark=2e-12 rl=1000000000000.0
Iphoto51 pd51 0 9.670932456851004e-09
Vsel51 sel51 0 PWL(0 0 0.01207 0 0.01207002 3.3 0.0121099 3.3 0.01210992 0)
X51 pd51 vr rst rg sg sel51 br bs pixel ch=1e-09 ci=1e-10 dark=2e-12 rl=1000000000000.0
Iphoto52 pd52 0 9.670932456851004e-09
Vsel52 sel52 0 PWL(0 0 0.01211 0 0.01211002 3.3 0.0121499 3.3 0.01214992 0)
X52 pd52 vr rst rg sg sel52 br bs pixel ch=1e-09 ci=1e-10 dark=2e-12 rl=1000000000000.0
Iphoto53 pd53 0 9.670932456851004e-09
Vsel53 sel53 0 PWL(0 0 0.01215 0 0.01215002 3.3 0.0121899 3.3 0.01218992 0)
X53 pd53 vr rst rg sg sel53 br bs pixel ch=1e-09 ci=1e-10 dark=2e-12 rl=1000000000000.0
Iphoto54 pd54 0 1.0945845879614354e-09
Vsel54 sel54 0 PWL(0 0 0.01219 0 0.01219002 3.3 0.0122299 3.3 0.01222992 0)
X54 pd54 vr rst rg sg sel54 br bs pixel ch=1e-09 ci=1e-10 dark=2e-12 rl=1000000000000.0
Iphoto55 pd55 0 1.4165705640334636e-10
Vsel55 sel55 0 PWL(0 0 0.01223 0 0.01223002 3.3 0.0122699 3.3 0.01226992 0)
X55 pd55 vr rst rg sg sel55 br bs pixel ch=1e-09 ci=1e-10 dark=2e-12 rl=1000000000000.0
Iphoto56 pd56 0 1.4165705640334636e-10
Vsel56 sel56 0 PWL(0 0 0.01227 0 0.01227002 3.3 0.0123099 3.3 0.01230992 0)
X56 pd56 vr rst rg sg sel56 br bs pixel ch=1e-09 ci=1e-10 dark=2e-12 rl=1000000000000.0
Iphoto57 pd57 0 1.4165705640334636e-10
Vsel57 sel57 0 PWL(0 0 0.01231 0 0.01231002 3.3 0.0123499 3.3 0.01234992 0)
X57 pd57 vr rst rg sg sel57 br bs pixel ch=1e-09 ci=1e-10 dark=2e-12 rl=1000000000000.0
Iphoto58 pd58 0 1.4165705640334636e-10
Vsel58 sel58 0 PWL(0 0 0.01235 0 0.01235002 3.3 0.0123899 3.3 0.01238992 0)
X58 pd58 vr rst rg sg sel58 br bs pixel ch=1e-09 ci=1e-10 dark=2e-12 rl=1000000000000.0
Iphoto59 pd59 0 1.4165705640334636e-10
Vsel59 sel59 0 PWL(0 0 0.01239 0 0.01239002 3.3 0.0124299 3.3 0.01242992 0)
X59 pd59 vr rst rg sg sel59 br bs pixel ch=1e-09 ci=1e-10 dark=2e-12 rl=1000000000000.0
Iphoto60 pd60 0 1.4165705640334636e-10
Vsel60 sel60 0 PWL(0 0 0.01243 0 0.01243002 3.3 0.0124699 3.3 0.01246992 0)
X60 pd60 vr rst rg sg sel60 br bs pixel ch=1e-09 ci=1e-10 dark=2e-12 rl=1000000000000.0
Iphoto61 pd61 0 1.4165705640334636e-10
Vsel61 sel61 0 PWL(0 0 0.01247 0 0.01247002 3.3 0.0125099 3.3 0.01250992 0)
X61 pd61 vr rst rg sg sel61 br bs pixel ch=1e-09 ci=1e-10 dark=2e-12 rl=1000000000000.0
Iphoto62 pd62 0 1.4165705640334636e-10
Vsel62 sel62 0 PWL(0 0 0.01251 0 0.01251002 3.3 0.0125499 3.3 0.01254992 0)
X62 pd62 vr rst rg sg sel62 br bs pixel ch=1e-09 ci=1e-10 dark=2e-12 rl=1000000000000.0
Iphoto63 pd63 0 1.4165705640334636e-10
Vsel63 sel63 0 PWL(0 0 0.01255 0 0.01255002 3.3 0.0125899 3.3 0.01258992 0)
X63 pd63 vr rst rg sg sel63 br bs pixel ch=1e-09 ci=1e-10 dark=2e-12 rl=1000000000000.0
Iphoto64 pd64 0 1.4165705640334636e-10
Vsel64 sel64 0 PWL(0 0 0.01259 0 0.01259002 3.3 0.0126299 3.3 0.01262992 0)
X64 pd64 vr rst rg sg sel64 br bs pixel ch=1e-09 ci=1e-10 dark=2e-12 rl=1000000000000.0
Iphoto65 pd65 0 1.4165705640334636e-10
Vsel65 sel65 0 PWL(0 0 0.01263 0 0.01263002 3.3 0.0126699 3.3 0.01266992 0)
X65 pd65 vr rst rg sg sel65 br bs pixel ch=1e-09 ci=1e-10 dark=2e-12 rl=1000000000000.0
Iphoto66 pd66 0 1.4165705640334636e-10
Vsel66 sel66 0 PWL(0 0 0.01267 0 0.01267002 3.3 0.0127099 3.3 0.01270992 0)
X66 pd66 vr rst rg sg sel66 br bs pixel ch=1e-09 ci=1e-10 dark=2e-12 rl=1000000000000.0
Iphoto67 pd67 0 1.4165705640334636e-10
Vsel67 sel67 0 PWL(0 0 0.01271 0 0.01271002 3.3 0.0127499 3.3 0.01274992 0)
X67 pd67 vr rst rg sg sel67 br bs pixel ch=1e-09 ci=1e-10 dark=2e-12 rl=1000000000000.0
Iphoto68 pd68 0 1.4165705640334636e-10
Vsel68 sel68 0 PWL(0 0 0.01275 0 0.01275002 3.3 0.0127899 3.3 0.01278992 0)
X68 pd68 vr rst rg sg sel68 br bs pixel ch=1e-09 ci=1e-10 dark=2e-12 rl=1000000000000.0
Iphoto69 pd69 0 1.4165705640334636e-10
Vsel69 sel69 0 PWL(0 0 0.01279 0 0.01279002 3.3 0.0128299 3.3 0.01282992 0)
X69 pd69 vr rst rg sg sel69 br bs pixel ch=1e-09 ci=1e-10 dark=2e-12 rl=1000000000000.0
Iphoto70 pd70 0 7.858895778190344e-11
Vsel70 sel70 0 PWL(0 0 0.01283 0 0.01283002 3.3 0.0128699 3.3 0.01286992 0)
X70 pd70 vr rst rg sg sel70 br bs pixel ch=1e-09 ci=1e-10 dark=2e-12 rl=1000000000000.0
Iphoto71 pd71 0 3.9321097824722527e-10
Vsel71 sel71 0 PWL(0 0 0.01287 0 0.01287002 3.3 0.0129099 3.3 0.01290992 0)
X71 pd71 vr rst rg sg sel71 br bs pixel ch=1e-09 ci=1e-10 dark=2e-12 rl=1000000000000.0
Iphoto72 pd72 0 1.028413779102266e-09
Vsel72 sel72 0 PWL(0 0 0.01291 0 0.01291002 3.3 0.0129499 3.3 0.01294992 0)
X72 pd72 vr rst rg sg sel72 br bs pixel ch=1e-09 ci=1e-10 dark=2e-12 rl=1000000000000.0
Iphoto73 pd73 0 2.0309817418456077e-09
Vsel73 sel73 0 PWL(0 0 0.01295 0 0.01295002 3.3 0.0129899 3.3 0.01298992 0)
X73 pd73 vr rst rg sg sel73 br bs pixel ch=1e-09 ci=1e-10 dark=2e-12 rl=1000000000000.0
Iphoto74 pd74 0 3.46481765806675e-09
Vsel74 sel74 0 PWL(0 0 0.01299 0 0.01299002 3.3 0.0130299 3.3 0.01302992 0)
X74 pd74 vr rst rg sg sel74 br bs pixel ch=1e-09 ci=1e-10 dark=2e-12 rl=1000000000000.0
Iphoto75 pd75 0 5.364075310528279e-09
Vsel75 sel75 0 PWL(0 0 0.01303 0 0.01303002 3.3 0.0130699 3.3 0.01306992 0)
X75 pd75 vr rst rg sg sel75 br bs pixel ch=1e-09 ci=1e-10 dark=2e-12 rl=1000000000000.0
Iphoto76 pd76 0 7.76431033015251e-09
Vsel76 sel76 0 PWL(0 0 0.01307 0 0.01307002 3.3 0.0131099 3.3 0.01310992 0)
X76 pd76 vr rst rg sg sel76 br bs pixel ch=1e-09 ci=1e-10 dark=2e-12 rl=1000000000000.0
Iphoto77 pd77 0 1.0672264382243156e-08
Vsel77 sel77 0 PWL(0 0 0.01311 0 0.01311002 3.3 0.0131499 3.3 0.01314992 0)
X77 pd77 vr rst rg sg sel77 br bs pixel ch=1e-09 ci=1e-10 dark=2e-12 rl=1000000000000.0
Iphoto78 pd78 0 1.4177565827965736e-08
Vsel78 sel78 0 PWL(0 0 0.01315 0 0.01315002 3.3 0.0131899 3.3 0.01318992 0)
X78 pd78 vr rst rg sg sel78 br bs pixel ch=1e-09 ci=1e-10 dark=2e-12 rl=1000000000000.0
Iphoto79 pd79 0 1.8242272809147833e-08
Vsel79 sel79 0 PWL(0 0 0.01319 0 0.01319002 3.3 0.0132299 3.3 0.01322992 0)
X79 pd79 vr rst rg sg sel79 br bs pixel ch=1e-09 ci=1e-10 dark=2e-12 rl=1000000000000.0
Iphoto80 pd80 0 7.858895778190344e-11
Vsel80 sel80 0 PWL(0 0 0.01323 0 0.01323002 3.3 0.0132699 3.3 0.01326992 0)
X80 pd80 vr rst rg sg sel80 br bs pixel ch=1e-09 ci=1e-10 dark=2e-12 rl=1000000000000.0
Iphoto81 pd81 0 3.9321097824722527e-10
Vsel81 sel81 0 PWL(0 0 0.01327 0 0.01327002 3.3 0.0133099 3.3 0.01330992 0)
X81 pd81 vr rst rg sg sel81 br bs pixel ch=1e-09 ci=1e-10 dark=2e-12 rl=1000000000000.0
Iphoto82 pd82 0 1.028413779102266e-09
Vsel82 sel82 0 PWL(0 0 0.01331 0 0.01331002 3.3 0.0133499 3.3 0.01334992 0)
X82 pd82 vr rst rg sg sel82 br bs pixel ch=1e-09 ci=1e-10 dark=2e-12 rl=1000000000000.0
Iphoto83 pd83 0 2.0309817418456077e-09
Vsel83 sel83 0 PWL(0 0 0.01335 0 0.01335002 3.3 0.0133899 3.3 0.01338992 0)
X83 pd83 vr rst rg sg sel83 br bs pixel ch=1e-09 ci=1e-10 dark=2e-12 rl=1000000000000.0
Iphoto84 pd84 0 3.46481765806675e-09
Vsel84 sel84 0 PWL(0 0 0.01339 0 0.01339002 3.3 0.0134299 3.3 0.01342992 0)
X84 pd84 vr rst rg sg sel84 br bs pixel ch=1e-09 ci=1e-10 dark=2e-12 rl=1000000000000.0
Iphoto85 pd85 0 5.364075310528279e-09
Vsel85 sel85 0 PWL(0 0 0.01343 0 0.01343002 3.3 0.0134699 3.3 0.01346992 0)
X85 pd85 vr rst rg sg sel85 br bs pixel ch=1e-09 ci=1e-10 dark=2e-12 rl=1000000000000.0
Iphoto86 pd86 0 7.76431033015251e-09
Vsel86 sel86 0 PWL(0 0 0.01347 0 0.01347002 3.3 0.0135099 3.3 0.01350992 0)
X86 pd86 vr rst rg sg sel86 br bs pixel ch=1e-09 ci=1e-10 dark=2e-12 rl=1000000000000.0
Iphoto87 pd87 0 1.0672264382243156e-08
Vsel87 sel87 0 PWL(0 0 0.01351 0 0.01351002 3.3 0.0135499 3.3 0.01354992 0)
X87 pd87 vr rst rg sg sel87 br bs pixel ch=1e-09 ci=1e-10 dark=2e-12 rl=1000000000000.0
Iphoto88 pd88 0 1.4177565827965736e-08
Vsel88 sel88 0 PWL(0 0 0.01355 0 0.01355002 3.3 0.0135899 3.3 0.01358992 0)
X88 pd88 vr rst rg sg sel88 br bs pixel ch=1e-09 ci=1e-10 dark=2e-12 rl=1000000000000.0
Iphoto89 pd89 0 1.8242272809147833e-08
Vsel89 sel89 0 PWL(0 0 0.01359 0 0.01359002 3.3 0.0136299 3.3 0.01362992 0)
X89 pd89 vr rst rg sg sel89 br bs pixel ch=1e-09 ci=1e-10 dark=2e-12 rl=1000000000000.0
Iphoto90 pd90 0 1.4165705640334636e-10
Vsel90 sel90 0 PWL(0 0 0.01363 0 0.01363002 3.3 0.0136699 3.3 0.01366992 0)
X90 pd90 vr rst rg sg sel90 br bs pixel ch=1e-09 ci=1e-10 dark=2e-12 rl=1000000000000.0
Iphoto91 pd91 0 1.4165705640334636e-10
Vsel91 sel91 0 PWL(0 0 0.01367 0 0.01367002 3.3 0.0137099 3.3 0.01370992 0)
X91 pd91 vr rst rg sg sel91 br bs pixel ch=1e-09 ci=1e-10 dark=2e-12 rl=1000000000000.0
Iphoto92 pd92 0 1.4165705640334636e-10
Vsel92 sel92 0 PWL(0 0 0.01371 0 0.01371002 3.3 0.0137499 3.3 0.01374992 0)
X92 pd92 vr rst rg sg sel92 br bs pixel ch=1e-09 ci=1e-10 dark=2e-12 rl=1000000000000.0
Iphoto93 pd93 0 1.4165705640334636e-10
Vsel93 sel93 0 PWL(0 0 0.01375 0 0.01375002 3.3 0.0137899 3.3 0.01378992 0)
X93 pd93 vr rst rg sg sel93 br bs pixel ch=1e-09 ci=1e-10 dark=2e-12 rl=1000000000000.0
Iphoto94 pd94 0 1.4165705640334636e-10
Vsel94 sel94 0 PWL(0 0 0.01379 0 0.01379002 3.3 0.0138299 3.3 0.01382992 0)
X94 pd94 vr rst rg sg sel94 br bs pixel ch=1e-09 ci=1e-10 dark=2e-12 rl=1000000000000.0
Iphoto95 pd95 0 1.4165705640334636e-10
Vsel95 sel95 0 PWL(0 0 0.01383 0 0.01383002 3.3 0.0138699 3.3 0.01386992 0)
X95 pd95 vr rst rg sg sel95 br bs pixel ch=1e-09 ci=1e-10 dark=2e-12 rl=1000000000000.0
Iphoto96 pd96 0 1.4165705640334636e-10
Vsel96 sel96 0 PWL(0 0 0.01387 0 0.01387002 3.3 0.0139099 3.3 0.01390992 0)
X96 pd96 vr rst rg sg sel96 br bs pixel ch=1e-09 ci=1e-10 dark=2e-12 rl=1000000000000.0
Iphoto97 pd97 0 1.4165705640334636e-10
Vsel97 sel97 0 PWL(0 0 0.01391 0 0.01391002 3.3 0.0139499 3.3 0.01394992 0)
X97 pd97 vr rst rg sg sel97 br bs pixel ch=1e-09 ci=1e-10 dark=2e-12 rl=1000000000000.0
Iphoto98 pd98 0 1.4165705640334636e-10
Vsel98 sel98 0 PWL(0 0 0.01395 0 0.01395002 3.3 0.0139899 3.3 0.01398992 0)
X98 pd98 vr rst rg sg sel98 br bs pixel ch=1e-09 ci=1e-10 dark=2e-12 rl=1000000000000.0
Iphoto99 pd99 0 1.4165705640334636e-10
Vsel99 sel99 0 PWL(0 0 0.01399 0 0.01399002 3.3 0.0140299 3.3 0.01402992 0)
X99 pd99 vr rst rg sg sel99 br bs pixel ch=1e-09 ci=1e-10 dark=2e-12 rl=1000000000000.0

.global vdd
.model gate SW(Ron=50 Roff=1e14 Vt=1.65 Vh=0.05)
.model silicon D(Is=1e-14 N=1.2)

* Voltage-controlled channel for static mode and feedback selections
.subckt select a b control
Bchannel a b I=v(a,b)*(v(control)>1.65 ? 0.02 : 1e-14)
.ends select
Vblack black 0 0.1
Vnom nominal 0 3.0
Vcds cg 0 3.3
Vbypass bg 0 0
Xref br ref cg select
Xnom nominal ref bg select
Rplus ref plus 1meg
Rblack plus black 1meg
Rminus bs minus 1meg
Rdiff cds minus 1meg
Xdiff plus minus cds amp
Xgain cds fb pga amp
Vmulti multi 0 0
Xbottom bot black multi select
Rg fb bot 9950
Vg1 g1 0 3.3
Rf1 pga tap1 0.01
Xf1 tap1 fb g1 select
Vg2 g2 0 0
Rf2 pga tap2 9950
Xf2 tap2 fb g2 select
Vg4 g4 0 0
Rf4 pga tap4 29950
Xf4 tap4 fb g4 select
Vg8 g8 0 0
Rf8 pga tap8 69950
Xf8 tap8 fb g8 select
Vg16 g16 0 0
Rf16 pga tap16 149950
Xf16 tap16 fb g16 select

.model comp D(Is=1n N=1.5)
Rcomp pga knee 10k
Dcomp knee black comp
Xcomp knee compbuf compbuf amp
Vlin lin 0 3.3
Vlog logsel 0 0
Xlin pga mode lin select
Xlog compbuf mode logsel select
Rfilter mode filt 9950
Cfilter filt 0 1.9999999999999998e-10
Xfilter filt filtered filtered amp
Xdriver filtered driven driven amp
Riso driven adc 47
Cadc adc 0 20p
Radc adc 0 10meg

Rbr br 0 1T
Rbs bs 0 1T
Cbr br 0 30p
Cbs bs 0 30p
.temp 27.0
.options gmin=1e-15 reltol=2e-5 abstol=1e-14 vntol=1e-7 method=gear
.save v(pd0) v(x0.hr) v(x0.hs) v(br) v(bs) v(cds) v(pga) v(filtered) v(adc)
.tran 4.000000000000001e-06 0.01403 0 0.0003333333333333333
.end
