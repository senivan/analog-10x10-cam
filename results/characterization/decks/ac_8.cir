Front end small signal bench

.global vdd
.model gate SW(Ron=50 Roff=1e14 Vt=1.65 Vh=0.05)
.model silicon D(Is=1e-14 N=1.2)
.subckt amp plus minus out

* Dominant pole, 4 MHz GBW, 100k DC gain, 4 V/us slew, rail clamps
Bgm 0 pole I=max(-400u,min(400u,2.513m*(v(plus,minus)+20u)))
Rp pole 0 39.79meg
Cp pole 0 100p
Brails pole 0 I=(min(0,v(pole)-0.02)+max(0,v(pole)-v(vdd)+0.02))/2
Ebuf drive 0 pole 0 1
Rout drive out 10

.ends amp

* Voltage-controlled channel for static mode and feedback selections
.subckt select a b control
Bchannel a b I=v(a,b)*(v(control)>1.65 ? 0.02 : 1e-14)
.ends select
Vblack black 0 0.1
Vnom nominal 0 3.0
Vcds cg 0 3.3
Vbypass bg 0 0
Xref br ref cg select
Xnom nominal ref bg select
Rplus ref plus 1meg
Rblack plus black 1meg
Rminus bs minus 1meg
Rdiff cds minus 1meg
Xdiff plus minus cds amp
Xgain cds fb pga amp
Vmulti multi 0 3.3
Xbottom bot black multi select
Rg fb bot 9950
Vg1 g1 0 0
Rf1 pga tap1 0.01
Xf1 tap1 fb g1 select
Vg2 g2 0 0
Rf2 pga tap2 9950
Xf2 tap2 fb g2 select
Vg4 g4 0 0
Rf4 pga tap4 29950
Xf4 tap4 fb g4 select
Vg8 g8 0 3.3
Rf8 pga tap8 69950
Xf8 tap8 fb g8 select
Vg16 g16 0 0
Rf16 pga tap16 149950
Xf16 tap16 fb g16 select

.model comp D(Is=1n N=1.5)
Rcomp pga knee 10k
Dcomp knee black comp
Xcomp knee compbuf compbuf amp
Vlin lin 0 3.3
Vlog logsel 0 0
Xlin pga mode lin select
Xlog compbuf mode logsel select
Rfilter mode filt 9950
Cfilter filt 0 1.9999999999999998e-10
Xfilter filt filtered filtered amp
Xdriver filtered driven driven amp
Riso driven adc 47
Cadc adc 0 20p
Radc adc 0 10meg

Vdd vdd 0 5
Vr br 0 DC 3 AC 1
Vs bs 0 2.98
.save v(cds) v(pga) v(adc)
.ac dec 24 100 100meg
.end
