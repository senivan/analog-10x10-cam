.title Discrete component global shutter
Xb0 adc0 cds0 pga0 filtered0 br0 bs0 bank0
* TL081 OPERATIONAL AMPLIFIER "MACROMODEL" SUBCIRCUIT
* CREATED USING PARTS RELEASE 4.01 ON 06/16/89 AT 13:08
* (REV N/A)      SUPPLY VOLTAGE: +/-15V
* CONNECTIONS:   NON-INVERTING INPUT
*                | INVERTING INPUT
*                | | POSITIVE POWER SUPPLY
*                | | | NEGATIVE POWER SUPPLY
*                | | | | OUTPUT
*                | | | | |
.SUBCKT TL081    1 2 3 4 5
*
  C1   11 12 3.498E-12
  C2    6  7 15.00E-12
  DC    5 53 DX
  DE   54  5 DX
  DLP  90 91 DX
  DLN  92 90 DX
  DP    4  3 DX
  Ehalf mid 0 3 0 .5
Eground 99 mid 4 0 .5
  Fsum0 7 99 VB 4.715meg
Fsum1 7 99 VC -5meg
Fsum2 7 99 VE 5meg
Fsum3 7 99 VLP 5meg
Fsum4 7 99 VLN -5meg
  GA    6  0 11 12 282.8E-6
  GCM   0  6 10 99 8.942E-9
  ISS   3 10 DC 195.0E-6
  HLIM 90  0 VLIM 1K
  J1   11  2 10 JX
  J2   12  1 10 JX
  R2    6  9 100.0E3
  RD1   4 11 3.536E3
  RD2   4 12 3.536E3
  RO1   8  5 150
  RO2   7 99 150
  RP    3  4 2.143E3
  RSS  10 99 1.026E6
  VB    9  0 DC 0
  VC    3 53 DC 2.200
  VE   54  4 DC 2.200
  VLIM  7  8 DC 0
  VLP  91  0 DC 25
  VLN   0 92 DC 25
.MODEL DX D(IS=800.0E-18)
.MODEL JX PJF(IS=15.00E-12 BETA=270.1E-6 VTO=-1)
.ENDS
* ALD1106PBL. Published level-1 fit, overlap in F/m; terminal parasitics below.
.model ald_n nmos(level=1 vto=.7 kp=245u gamma=.85 phi=.9 lambda=.029
+ cbd=.5p cbs=.5p cgdo=5n cgso=5n tox=30n is=10p tnom=25)
.subckt pass a b g
Mchannel a g b 0 ald_n w=20u l=10u
Rgate g 0 10T
Cpackage g 0 .6p
.ends pass

.subckt pin an ca params: idark=70p
.model s5971 D(is={idark+1e-18} n=1.2 cjo=11.73p vj=.7 m=.5 rs=5 tnom=25)
Dpin an ca s5971
.ends pin
* -*- spice -*-
* http://www.nxp.com/documents/spice_model/1N4148.prm
*
*******************************************
*
* 1N4148
*
* NXP Semiconductors
*
* High-speed diodes
*
* VRRM = 100V
* IFRM = 450 mA
* trr  = 4ns
*
* Package pinning does not match Spice model pinning.
* Package: SOD 27
*
* Package Pin 1 : Cathode
* Package Pin 2 : Anode
*
* Simulator: PSPICE
*
*******************************************
*
.SUBCKT 1N4148 1 2
*
* The resistor R1 does not reflect
* a physical device. Instead it
* improves modeling in the reverse
* mode of operation.
*
R1 1 2 5.827E+9
D1 1 2 1N4148
*
.MODEL 1N4148 D
+ IS = 4.352E-9
+ N = 1.906
+ BV = 110
+ IBV = 0.0001
+ RS = 0.6458
+ CJO = 7.048E-13
+ VJ = 0.869
+ M = 0.03
+ FC = 0.5
+ TT = 3.48E-9
.ENDS
*

.subckt pixel pd vr rst rg sg row br bs vp vn params: ci=100p ch=1n rl=1T dark=70p
Xphoto 0 pd pin idark={dark}
Cint pd 0 {ci}
Rint pd 0 10T
Xreset vr pd rst pass
Xbuf pd out vp vn out TL081
Risol out drive 100
XsampleR drive hr rg pass
XsampleS drive hs sg pass
Chr hr 0 {ch}
Chs hs 0 {ch}
Rhr hr 0 {rl}
Rhs hs 0 {rl}
XrowR hr br row pass
XrowS hs bs row pass
.ends pixel

.subckt chain br bs nominal black vhi vp vn cds pga filtered adc
Xbr br rb vp vn rb TL081
Xbs bs sb vp vn sb TL081
Xcds rb ref vhi pass
Xbypass nominal ref 0 pass
Xlinear pga mode vhi pass
Xcomp compout mode 0 pass

Rp ref plus 100k
Rb plus black 100k
Rm sb minus 100k
Rf cds minus 100k
Xdiff plus minus vp vn cds TL081
Xgain cds fb vp vn pga TL081
Xbottom bot black 0 pass
Rground fb bot 100k
Rgain1 pga tap1 1
Xgain1 tap1 fb vhi pass
Rgain2 pga tap2 100000
Xgain2 tap2 fb 0 pass
Rgain4 pga tap4 300000
Xgain4 tap4 fb 0 pass
Rgain8 pga tap8 700000
Xgain8 tap8 fb 0 pass
Rgain16 pga tap16 1500000
Xgain16 tap16 fb 0 pass

Rcomp pga knee 10k
Xdiode knee black 1N4148
Xknee knee compout vp vn compout TL081
Rfilter mode filt 10k
Cfilter filt 0 1.9999999999999998e-10
Xfilter filt filtered vp vn filtered TL081
Xdriver filtered driven vp vn driven TL081
Riso driven adc 47
Cadc adc 0 20p
Radc adc 0 10meg
.ends chain

.subckt bank0 adc cds pga filtered br bs
Vrail rail 0 5.0
Vplus vp 0 7.5
Vminus vn 0 -7.5
Vlogic high 0 9
Rvrtop rail wvr 4000.0
Rvrbot wvr 0 6000.0
Xvr wvr bufvr vp vn bufvr TL081
Risovr bufvr vr 100

Rnominaltop rail wnominal 4000.0
Rnominalbot wnominal 0 6000.0
Xnominal wnominal bufnominal vp vn bufnominal TL081
Risonominal bufnominal nominal 100

Rblacktop rail wblack 9800.0
Rblackbot wblack 0 200.0
Xblack wblack bufblack vp vn bufblack TL081
Risoblack bufblack black 100

Vrst srcrst 0 PWL(0 9 2e-05 9 2.002e-05 0)
Rrst srcrst rst 33
Vrg srcrg 0 PWL(0 0 1e-06 0 1.02e-06 9 2.5e-05 9 2.502e-05 0)
Rrg srcrg rg 33
Vsg srcsg 0 PWL(0 0 0.010017 0 0.01001702 9 0.010025 9 0.01002502 0)
Rsg srcsg sg 33
Vrow0 srcrow0 0 PWL(0 0 0.01003 0 0.01003002 9 0.0104299 9 0.01042992 0)
Rrow0 srcrow0 row0 33
Vrow1 srcrow1 0 PWL(0 0 0.01043 0 0.01043002 9 0.0108299 9 0.01082992 0)
Rrow1 srcrow1 row1 33
Vrow2 srcrow2 0 PWL(0 0 0.01083 0 0.01083002 9 0.0112299 9 0.01122992 0)
Rrow2 srcrow2 row2 33
Vrow3 srcrow3 0 PWL(0 0 0.01123 0 0.01123002 9 0.0116299 9 0.01162992 0)
Rrow3 srcrow3 row3 33
Vrow4 srcrow4 0 PWL(0 0 0.01163 0 0.01163002 9 0.0120299 9 0.01202992 0)
Rrow4 srcrow4 row4 33
Vrow5 srcrow5 0 PWL(0 0 0.01203 0 0.01203002 9 0.0124299 9 0.01242992 0)
Rrow5 srcrow5 row5 33
Vrow6 srcrow6 0 PWL(0 0 0.01243 0 0.01243002 9 0.0128299 9 0.01282992 0)
Rrow6 srcrow6 row6 33
Vrow7 srcrow7 0 PWL(0 0 0.01283 0 0.01283002 9 0.0132299 9 0.01322992 0)
Rrow7 srcrow7 row7 33
Vrow8 srcrow8 0 PWL(0 0 0.01323 0 0.01323002 9 0.0136299 9 0.01362992 0)
Rrow8 srcrow8 row8 33
Vrow9 srcrow9 0 PWL(0 0 0.01363 0 0.01363002 9 0.0140299 9 0.01402992 0)
Rrow9 srcrow9 row9 33
Vcol0 srccol0 0 PWL(0 0 0.01003 0 0.01003002 9 0.0100699 9 0.01006992 0 0.01043 0 0.01043002 9 0.0104699 9 0.01046992 0 0.01083 0 0.01083002 9 0.0108699 9 0.01086992 0 0.01123 0 0.01123002 9 0.0112699 9 0.01126992 0 0.01163 0 0.01163002 9 0.0116699 9 0.01166992 0 0.01203 0 0.01203002 9 0.0120699 9 0.01206992 0 0.01243 0 0.01243002 9 0.0124699 9 0.01246992 0 0.01283 0 0.01283002 9 0.0128699 9 0.01286992 0 0.01323 0 0.01323002 9 0.0132699 9 0.01326992 0 0.01363 0 0.01363002 9 0.0136699 9 0.01366992 0)
Rcol0 srccol0 col0 33
Xmuxbr0 br0_0 br col0 pass
Xmuxbs0 bs0_0 bs col0 pass
Iphoto0 pd0 0 0.0
X0 pd0 vr rst rg sg row0 br0_0 bs0_0 vp vn pixel ci=1e-10 ch=1e-09 rl=1000000000000.0 dark=7e-11
Cbr0_0 br0_0 0 1p
Cbs0_0 bs0_0 0 1p
Iphoto10 pd10 0 1.98e-08
X10 pd10 vr rst rg sg row1 br0_1 bs0_1 vp vn pixel ci=1e-10 ch=1e-09 rl=1000000000000.0 dark=7e-11
Cbr0_1 br0_1 0 1p
Rbr0_1 br0_1 br0_0 .1
Cbs0_1 bs0_1 0 1p
Rbs0_1 bs0_1 bs0_0 .1
Iphoto20 pd20 0 0.0
X20 pd20 vr rst rg sg row2 br0_2 bs0_2 vp vn pixel ci=1e-10 ch=1e-09 rl=1000000000000.0 dark=7e-11
Cbr0_2 br0_2 0 1p
Rbr0_2 br0_2 br0_1 .1
Cbs0_2 bs0_2 0 1p
Rbs0_2 bs0_2 bs0_1 .1
Iphoto30 pd30 0 1.98e-08
X30 pd30 vr rst rg sg row3 br0_3 bs0_3 vp vn pixel ci=1e-10 ch=1e-09 rl=1000000000000.0 dark=7e-11
Cbr0_3 br0_3 0 1p
Rbr0_3 br0_3 br0_2 .1
Cbs0_3 bs0_3 0 1p
Rbs0_3 bs0_3 bs0_2 .1
Iphoto40 pd40 0 0.0
X40 pd40 vr rst rg sg row4 br0_4 bs0_4 vp vn pixel ci=1e-10 ch=1e-09 rl=1000000000000.0 dark=7e-11
Cbr0_4 br0_4 0 1p
Rbr0_4 br0_4 br0_3 .1
Cbs0_4 bs0_4 0 1p
Rbs0_4 bs0_4 bs0_3 .1
Iphoto50 pd50 0 1.98e-08
X50 pd50 vr rst rg sg row5 br0_5 bs0_5 vp vn pixel ci=1e-10 ch=1e-09 rl=1000000000000.0 dark=7e-11
Cbr0_5 br0_5 0 1p
Rbr0_5 br0_5 br0_4 .1
Cbs0_5 bs0_5 0 1p
Rbs0_5 bs0_5 bs0_4 .1
Iphoto60 pd60 0 0.0
X60 pd60 vr rst rg sg row6 br0_6 bs0_6 vp vn pixel ci=1e-10 ch=1e-09 rl=1000000000000.0 dark=7e-11
Cbr0_6 br0_6 0 1p
Rbr0_6 br0_6 br0_5 .1
Cbs0_6 bs0_6 0 1p
Rbs0_6 bs0_6 bs0_5 .1
Iphoto70 pd70 0 1.98e-08
X70 pd70 vr rst rg sg row7 br0_7 bs0_7 vp vn pixel ci=1e-10 ch=1e-09 rl=1000000000000.0 dark=7e-11
Cbr0_7 br0_7 0 1p
Rbr0_7 br0_7 br0_6 .1
Cbs0_7 bs0_7 0 1p
Rbs0_7 bs0_7 bs0_6 .1
Iphoto80 pd80 0 0.0
X80 pd80 vr rst rg sg row8 br0_8 bs0_8 vp vn pixel ci=1e-10 ch=1e-09 rl=1000000000000.0 dark=7e-11
Cbr0_8 br0_8 0 1p
Rbr0_8 br0_8 br0_7 .1
Cbs0_8 bs0_8 0 1p
Rbs0_8 bs0_8 bs0_7 .1
Iphoto90 pd90 0 1.98e-08
X90 pd90 vr rst rg sg row9 br0_9 bs0_9 vp vn pixel ci=1e-10 ch=1e-09 rl=1000000000000.0 dark=7e-11
Cbr0_9 br0_9 0 1p
Rbr0_9 br0_9 br0_8 .1
Cbs0_9 bs0_9 0 1p
Rbs0_9 bs0_9 bs0_8 .1
Vcol1 srccol1 0 PWL(0 0 0.01007 0 0.01007002 9 0.0101099 9 0.01010992 0 0.01047 0 0.01047002 9 0.0105099 9 0.01050992 0 0.01087 0 0.01087002 9 0.0109099 9 0.01090992 0 0.01127 0 0.01127002 9 0.0113099 9 0.01130992 0 0.01167 0 0.01167002 9 0.0117099 9 0.01170992 0 0.01207 0 0.01207002 9 0.0121099 9 0.01210992 0 0.01247 0 0.01247002 9 0.0125099 9 0.01250992 0 0.01287 0 0.01287002 9 0.0129099 9 0.01290992 0 0.01327 0 0.01327002 9 0.0133099 9 0.01330992 0 0.01367 0 0.01367002 9 0.0137099 9 0.01370992 0)
Rcol1 srccol1 col1 33
Xmuxbr1 br1_0 br col1 pass
Xmuxbs1 bs1_0 bs col1 pass
Iphoto1 pd1 0 1.98e-08
X1 pd1 vr rst rg sg row0 br1_0 bs1_0 vp vn pixel ci=1e-10 ch=1e-09 rl=1000000000000.0 dark=7e-11
Cbr1_0 br1_0 0 1p
Cbs1_0 bs1_0 0 1p
Iphoto11 pd11 0 0.0
X11 pd11 vr rst rg sg row1 br1_1 bs1_1 vp vn pixel ci=1e-10 ch=1e-09 rl=1000000000000.0 dark=7e-11
Cbr1_1 br1_1 0 1p
Rbr1_1 br1_1 br1_0 .1
Cbs1_1 bs1_1 0 1p
Rbs1_1 bs1_1 bs1_0 .1
Iphoto21 pd21 0 1.98e-08
X21 pd21 vr rst rg sg row2 br1_2 bs1_2 vp vn pixel ci=1e-10 ch=1e-09 rl=1000000000000.0 dark=7e-11
Cbr1_2 br1_2 0 1p
Rbr1_2 br1_2 br1_1 .1
Cbs1_2 bs1_2 0 1p
Rbs1_2 bs1_2 bs1_1 .1
Iphoto31 pd31 0 0.0
X31 pd31 vr rst rg sg row3 br1_3 bs1_3 vp vn pixel ci=1e-10 ch=1e-09 rl=1000000000000.0 dark=7e-11
Cbr1_3 br1_3 0 1p
Rbr1_3 br1_3 br1_2 .1
Cbs1_3 bs1_3 0 1p
Rbs1_3 bs1_3 bs1_2 .1
Iphoto41 pd41 0 1.98e-08
X41 pd41 vr rst rg sg row4 br1_4 bs1_4 vp vn pixel ci=1e-10 ch=1e-09 rl=1000000000000.0 dark=7e-11
Cbr1_4 br1_4 0 1p
Rbr1_4 br1_4 br1_3 .1
Cbs1_4 bs1_4 0 1p
Rbs1_4 bs1_4 bs1_3 .1
Iphoto51 pd51 0 0.0
X51 pd51 vr rst rg sg row5 br1_5 bs1_5 vp vn pixel ci=1e-10 ch=1e-09 rl=1000000000000.0 dark=7e-11
Cbr1_5 br1_5 0 1p
Rbr1_5 br1_5 br1_4 .1
Cbs1_5 bs1_5 0 1p
Rbs1_5 bs1_5 bs1_4 .1
Iphoto61 pd61 0 1.98e-08
X61 pd61 vr rst rg sg row6 br1_6 bs1_6 vp vn pixel ci=1e-10 ch=1e-09 rl=1000000000000.0 dark=7e-11
Cbr1_6 br1_6 0 1p
Rbr1_6 br1_6 br1_5 .1
Cbs1_6 bs1_6 0 1p
Rbs1_6 bs1_6 bs1_5 .1
Iphoto71 pd71 0 0.0
X71 pd71 vr rst rg sg row7 br1_7 bs1_7 vp vn pixel ci=1e-10 ch=1e-09 rl=1000000000000.0 dark=7e-11
Cbr1_7 br1_7 0 1p
Rbr1_7 br1_7 br1_6 .1
Cbs1_7 bs1_7 0 1p
Rbs1_7 bs1_7 bs1_6 .1
Iphoto81 pd81 0 1.98e-08
X81 pd81 vr rst rg sg row8 br1_8 bs1_8 vp vn pixel ci=1e-10 ch=1e-09 rl=1000000000000.0 dark=7e-11
Cbr1_8 br1_8 0 1p
Rbr1_8 br1_8 br1_7 .1
Cbs1_8 bs1_8 0 1p
Rbs1_8 bs1_8 bs1_7 .1
Iphoto91 pd91 0 0.0
X91 pd91 vr rst rg sg row9 br1_9 bs1_9 vp vn pixel ci=1e-10 ch=1e-09 rl=1000000000000.0 dark=7e-11
Cbr1_9 br1_9 0 1p
Rbr1_9 br1_9 br1_8 .1
Cbs1_9 bs1_9 0 1p
Rbs1_9 bs1_9 bs1_8 .1
Vcol2 srccol2 0 PWL(0 0 0.01011 0 0.01011002 9 0.0101499 9 0.01014992 0 0.01051 0 0.01051002 9 0.0105499 9 0.01054992 0 0.01091 0 0.01091002 9 0.0109499 9 0.01094992 0 0.01131 0 0.01131002 9 0.0113499 9 0.01134992 0 0.01171 0 0.01171002 9 0.0117499 9 0.01174992 0 0.01211 0 0.01211002 9 0.0121499 9 0.01214992 0 0.01251 0 0.01251002 9 0.0125499 9 0.01254992 0 0.01291 0 0.01291002 9 0.0129499 9 0.01294992 0 0.01331 0 0.01331002 9 0.0133499 9 0.01334992 0 0.01371 0 0.01371002 9 0.0137499 9 0.01374992 0)
Rcol2 srccol2 col2 33
Xmuxbr2 br2_0 br col2 pass
Xmuxbs2 bs2_0 bs col2 pass
Iphoto2 pd2 0 0.0
X2 pd2 vr rst rg sg row0 br2_0 bs2_0 vp vn pixel ci=1e-10 ch=1e-09 rl=1000000000000.0 dark=7e-11
Cbr2_0 br2_0 0 1p
Cbs2_0 bs2_0 0 1p
Iphoto12 pd12 0 1.98e-08
X12 pd12 vr rst rg sg row1 br2_1 bs2_1 vp vn pixel ci=1e-10 ch=1e-09 rl=1000000000000.0 dark=7e-11
Cbr2_1 br2_1 0 1p
Rbr2_1 br2_1 br2_0 .1
Cbs2_1 bs2_1 0 1p
Rbs2_1 bs2_1 bs2_0 .1
Iphoto22 pd22 0 0.0
X22 pd22 vr rst rg sg row2 br2_2 bs2_2 vp vn pixel ci=1e-10 ch=1e-09 rl=1000000000000.0 dark=7e-11
Cbr2_2 br2_2 0 1p
Rbr2_2 br2_2 br2_1 .1
Cbs2_2 bs2_2 0 1p
Rbs2_2 bs2_2 bs2_1 .1
Iphoto32 pd32 0 1.98e-08
X32 pd32 vr rst rg sg row3 br2_3 bs2_3 vp vn pixel ci=1e-10 ch=1e-09 rl=1000000000000.0 dark=7e-11
Cbr2_3 br2_3 0 1p
Rbr2_3 br2_3 br2_2 .1
Cbs2_3 bs2_3 0 1p
Rbs2_3 bs2_3 bs2_2 .1
Iphoto42 pd42 0 0.0
X42 pd42 vr rst rg sg row4 br2_4 bs2_4 vp vn pixel ci=1e-10 ch=1e-09 rl=1000000000000.0 dark=7e-11
Cbr2_4 br2_4 0 1p
Rbr2_4 br2_4 br2_3 .1
Cbs2_4 bs2_4 0 1p
Rbs2_4 bs2_4 bs2_3 .1
Iphoto52 pd52 0 1.98e-08
X52 pd52 vr rst rg sg row5 br2_5 bs2_5 vp vn pixel ci=1e-10 ch=1e-09 rl=1000000000000.0 dark=7e-11
Cbr2_5 br2_5 0 1p
Rbr2_5 br2_5 br2_4 .1
Cbs2_5 bs2_5 0 1p
Rbs2_5 bs2_5 bs2_4 .1
Iphoto62 pd62 0 0.0
X62 pd62 vr rst rg sg row6 br2_6 bs2_6 vp vn pixel ci=1e-10 ch=1e-09 rl=1000000000000.0 dark=7e-11
Cbr2_6 br2_6 0 1p
Rbr2_6 br2_6 br2_5 .1
Cbs2_6 bs2_6 0 1p
Rbs2_6 bs2_6 bs2_5 .1
Iphoto72 pd72 0 1.98e-08
X72 pd72 vr rst rg sg row7 br2_7 bs2_7 vp vn pixel ci=1e-10 ch=1e-09 rl=1000000000000.0 dark=7e-11
Cbr2_7 br2_7 0 1p
Rbr2_7 br2_7 br2_6 .1
Cbs2_7 bs2_7 0 1p
Rbs2_7 bs2_7 bs2_6 .1
Iphoto82 pd82 0 0.0
X82 pd82 vr rst rg sg row8 br2_8 bs2_8 vp vn pixel ci=1e-10 ch=1e-09 rl=1000000000000.0 dark=7e-11
Cbr2_8 br2_8 0 1p
Rbr2_8 br2_8 br2_7 .1
Cbs2_8 bs2_8 0 1p
Rbs2_8 bs2_8 bs2_7 .1
Iphoto92 pd92 0 1.98e-08
X92 pd92 vr rst rg sg row9 br2_9 bs2_9 vp vn pixel ci=1e-10 ch=1e-09 rl=1000000000000.0 dark=7e-11
Cbr2_9 br2_9 0 1p
Rbr2_9 br2_9 br2_8 .1
Cbs2_9 bs2_9 0 1p
Rbs2_9 bs2_9 bs2_8 .1
Vcol3 srccol3 0 PWL(0 0 0.01015 0 0.01015002 9 0.0101899 9 0.01018992 0 0.01055 0 0.01055002 9 0.0105899 9 0.01058992 0 0.01095 0 0.01095002 9 0.0109899 9 0.01098992 0 0.01135 0 0.01135002 9 0.0113899 9 0.01138992 0 0.01175 0 0.01175002 9 0.0117899 9 0.01178992 0 0.01215 0 0.01215002 9 0.0121899 9 0.01218992 0 0.01255 0 0.01255002 9 0.0125899 9 0.01258992 0 0.01295 0 0.01295002 9 0.0129899 9 0.01298992 0 0.01335 0 0.01335002 9 0.0133899 9 0.01338992 0 0.01375 0 0.01375002 9 0.0137899 9 0.01378992 0)
Rcol3 srccol3 col3 33
Xmuxbr3 br3_0 br col3 pass
Xmuxbs3 bs3_0 bs col3 pass
Iphoto3 pd3 0 1.98e-08
X3 pd3 vr rst rg sg row0 br3_0 bs3_0 vp vn pixel ci=1e-10 ch=1e-09 rl=1000000000000.0 dark=7e-11
Cbr3_0 br3_0 0 1p
Cbs3_0 bs3_0 0 1p
Iphoto13 pd13 0 0.0
X13 pd13 vr rst rg sg row1 br3_1 bs3_1 vp vn pixel ci=1e-10 ch=1e-09 rl=1000000000000.0 dark=7e-11
Cbr3_1 br3_1 0 1p
Rbr3_1 br3_1 br3_0 .1
Cbs3_1 bs3_1 0 1p
Rbs3_1 bs3_1 bs3_0 .1
Iphoto23 pd23 0 1.98e-08
X23 pd23 vr rst rg sg row2 br3_2 bs3_2 vp vn pixel ci=1e-10 ch=1e-09 rl=1000000000000.0 dark=7e-11
Cbr3_2 br3_2 0 1p
Rbr3_2 br3_2 br3_1 .1
Cbs3_2 bs3_2 0 1p
Rbs3_2 bs3_2 bs3_1 .1
Iphoto33 pd33 0 0.0
X33 pd33 vr rst rg sg row3 br3_3 bs3_3 vp vn pixel ci=1e-10 ch=1e-09 rl=1000000000000.0 dark=7e-11
Cbr3_3 br3_3 0 1p
Rbr3_3 br3_3 br3_2 .1
Cbs3_3 bs3_3 0 1p
Rbs3_3 bs3_3 bs3_2 .1
Iphoto43 pd43 0 1.98e-08
X43 pd43 vr rst rg sg row4 br3_4 bs3_4 vp vn pixel ci=1e-10 ch=1e-09 rl=1000000000000.0 dark=7e-11
Cbr3_4 br3_4 0 1p
Rbr3_4 br3_4 br3_3 .1
Cbs3_4 bs3_4 0 1p
Rbs3_4 bs3_4 bs3_3 .1
Iphoto53 pd53 0 0.0
X53 pd53 vr rst rg sg row5 br3_5 bs3_5 vp vn pixel ci=1e-10 ch=1e-09 rl=1000000000000.0 dark=7e-11
Cbr3_5 br3_5 0 1p
Rbr3_5 br3_5 br3_4 .1
Cbs3_5 bs3_5 0 1p
Rbs3_5 bs3_5 bs3_4 .1
Iphoto63 pd63 0 1.98e-08
X63 pd63 vr rst rg sg row6 br3_6 bs3_6 vp vn pixel ci=1e-10 ch=1e-09 rl=1000000000000.0 dark=7e-11
Cbr3_6 br3_6 0 1p
Rbr3_6 br3_6 br3_5 .1
Cbs3_6 bs3_6 0 1p
Rbs3_6 bs3_6 bs3_5 .1
Iphoto73 pd73 0 0.0
X73 pd73 vr rst rg sg row7 br3_7 bs3_7 vp vn pixel ci=1e-10 ch=1e-09 rl=1000000000000.0 dark=7e-11
Cbr3_7 br3_7 0 1p
Rbr3_7 br3_7 br3_6 .1
Cbs3_7 bs3_7 0 1p
Rbs3_7 bs3_7 bs3_6 .1
Iphoto83 pd83 0 1.98e-08
X83 pd83 vr rst rg sg row8 br3_8 bs3_8 vp vn pixel ci=1e-10 ch=1e-09 rl=1000000000000.0 dark=7e-11
Cbr3_8 br3_8 0 1p
Rbr3_8 br3_8 br3_7 .1
Cbs3_8 bs3_8 0 1p
Rbs3_8 bs3_8 bs3_7 .1
Iphoto93 pd93 0 0.0
X93 pd93 vr rst rg sg row9 br3_9 bs3_9 vp vn pixel ci=1e-10 ch=1e-09 rl=1000000000000.0 dark=7e-11
Cbr3_9 br3_9 0 1p
Rbr3_9 br3_9 br3_8 .1
Cbs3_9 bs3_9 0 1p
Rbs3_9 bs3_9 bs3_8 .1
Vcol4 srccol4 0 PWL(0 0 0.01019 0 0.01019002 9 0.0102299 9 0.01022992 0 0.01059 0 0.01059002 9 0.0106299 9 0.01062992 0 0.01099 0 0.01099002 9 0.0110299 9 0.01102992 0 0.01139 0 0.01139002 9 0.0114299 9 0.01142992 0 0.01179 0 0.01179002 9 0.0118299 9 0.01182992 0 0.01219 0 0.01219002 9 0.0122299 9 0.01222992 0 0.01259 0 0.01259002 9 0.0126299 9 0.01262992 0 0.01299 0 0.01299002 9 0.0130299 9 0.01302992 0 0.01339 0 0.01339002 9 0.0134299 9 0.01342992 0 0.01379 0 0.01379002 9 0.0138299 9 0.01382992 0)
Rcol4 srccol4 col4 33
Xmuxbr4 br4_0 br col4 pass
Xmuxbs4 bs4_0 bs col4 pass
Iphoto4 pd4 0 0.0
X4 pd4 vr rst rg sg row0 br4_0 bs4_0 vp vn pixel ci=1e-10 ch=1e-09 rl=1000000000000.0 dark=7e-11
Cbr4_0 br4_0 0 1p
Cbs4_0 bs4_0 0 1p
Iphoto14 pd14 0 1.98e-08
X14 pd14 vr rst rg sg row1 br4_1 bs4_1 vp vn pixel ci=1e-10 ch=1e-09 rl=1000000000000.0 dark=7e-11
Cbr4_1 br4_1 0 1p
Rbr4_1 br4_1 br4_0 .1
Cbs4_1 bs4_1 0 1p
Rbs4_1 bs4_1 bs4_0 .1
Iphoto24 pd24 0 0.0
X24 pd24 vr rst rg sg row2 br4_2 bs4_2 vp vn pixel ci=1e-10 ch=1e-09 rl=1000000000000.0 dark=7e-11
Cbr4_2 br4_2 0 1p
Rbr4_2 br4_2 br4_1 .1
Cbs4_2 bs4_2 0 1p
Rbs4_2 bs4_2 bs4_1 .1
Iphoto34 pd34 0 1.98e-08
X34 pd34 vr rst rg sg row3 br4_3 bs4_3 vp vn pixel ci=1e-10 ch=1e-09 rl=1000000000000.0 dark=7e-11
Cbr4_3 br4_3 0 1p
Rbr4_3 br4_3 br4_2 .1
Cbs4_3 bs4_3 0 1p
Rbs4_3 bs4_3 bs4_2 .1
Iphoto44 pd44 0 0.0
X44 pd44 vr rst rg sg row4 br4_4 bs4_4 vp vn pixel ci=1e-10 ch=1e-09 rl=1000000000000.0 dark=7e-11
Cbr4_4 br4_4 0 1p
Rbr4_4 br4_4 br4_3 .1
Cbs4_4 bs4_4 0 1p
Rbs4_4 bs4_4 bs4_3 .1
Iphoto54 pd54 0 1.98e-08
X54 pd54 vr rst rg sg row5 br4_5 bs4_5 vp vn pixel ci=1e-10 ch=1e-09 rl=1000000000000.0 dark=7e-11
Cbr4_5 br4_5 0 1p
Rbr4_5 br4_5 br4_4 .1
Cbs4_5 bs4_5 0 1p
Rbs4_5 bs4_5 bs4_4 .1
Iphoto64 pd64 0 0.0
X64 pd64 vr rst rg sg row6 br4_6 bs4_6 vp vn pixel ci=1e-10 ch=1e-09 rl=1000000000000.0 dark=7e-11
Cbr4_6 br4_6 0 1p
Rbr4_6 br4_6 br4_5 .1
Cbs4_6 bs4_6 0 1p
Rbs4_6 bs4_6 bs4_5 .1
Iphoto74 pd74 0 1.98e-08
X74 pd74 vr rst rg sg row7 br4_7 bs4_7 vp vn pixel ci=1e-10 ch=1e-09 rl=1000000000000.0 dark=7e-11
Cbr4_7 br4_7 0 1p
Rbr4_7 br4_7 br4_6 .1
Cbs4_7 bs4_7 0 1p
Rbs4_7 bs4_7 bs4_6 .1
Iphoto84 pd84 0 0.0
X84 pd84 vr rst rg sg row8 br4_8 bs4_8 vp vn pixel ci=1e-10 ch=1e-09 rl=1000000000000.0 dark=7e-11
Cbr4_8 br4_8 0 1p
Rbr4_8 br4_8 br4_7 .1
Cbs4_8 bs4_8 0 1p
Rbs4_8 bs4_8 bs4_7 .1
Iphoto94 pd94 0 1.98e-08
X94 pd94 vr rst rg sg row9 br4_9 bs4_9 vp vn pixel ci=1e-10 ch=1e-09 rl=1000000000000.0 dark=7e-11
Cbr4_9 br4_9 0 1p
Rbr4_9 br4_9 br4_8 .1
Cbs4_9 bs4_9 0 1p
Rbs4_9 bs4_9 bs4_8 .1
Vcol5 srccol5 0 PWL(0 0 0.01023 0 0.01023002 9 0.0102699 9 0.01026992 0 0.01063 0 0.01063002 9 0.0106699 9 0.01066992 0 0.01103 0 0.01103002 9 0.0110699 9 0.01106992 0 0.01143 0 0.01143002 9 0.0114699 9 0.01146992 0 0.01183 0 0.01183002 9 0.0118699 9 0.01186992 0 0.01223 0 0.01223002 9 0.0122699 9 0.01226992 0 0.01263 0 0.01263002 9 0.0126699 9 0.01266992 0 0.01303 0 0.01303002 9 0.0130699 9 0.01306992 0 0.01343 0 0.01343002 9 0.0134699 9 0.01346992 0 0.01383 0 0.01383002 9 0.0138699 9 0.01386992 0)
Rcol5 srccol5 col5 33
Xmuxbr5 br5_0 br col5 pass
Xmuxbs5 bs5_0 bs col5 pass
Iphoto5 pd5 0 1.98e-08
X5 pd5 vr rst rg sg row0 br5_0 bs5_0 vp vn pixel ci=1e-10 ch=1e-09 rl=1000000000000.0 dark=7e-11
Cbr5_0 br5_0 0 1p
Cbs5_0 bs5_0 0 1p
Iphoto15 pd15 0 0.0
X15 pd15 vr rst rg sg row1 br5_1 bs5_1 vp vn pixel ci=1e-10 ch=1e-09 rl=1000000000000.0 dark=7e-11
Cbr5_1 br5_1 0 1p
Rbr5_1 br5_1 br5_0 .1
Cbs5_1 bs5_1 0 1p
Rbs5_1 bs5_1 bs5_0 .1
Iphoto25 pd25 0 1.98e-08
X25 pd25 vr rst rg sg row2 br5_2 bs5_2 vp vn pixel ci=1e-10 ch=1e-09 rl=1000000000000.0 dark=7e-11
Cbr5_2 br5_2 0 1p
Rbr5_2 br5_2 br5_1 .1
Cbs5_2 bs5_2 0 1p
Rbs5_2 bs5_2 bs5_1 .1
Iphoto35 pd35 0 0.0
X35 pd35 vr rst rg sg row3 br5_3 bs5_3 vp vn pixel ci=1e-10 ch=1e-09 rl=1000000000000.0 dark=7e-11
Cbr5_3 br5_3 0 1p
Rbr5_3 br5_3 br5_2 .1
Cbs5_3 bs5_3 0 1p
Rbs5_3 bs5_3 bs5_2 .1
Iphoto45 pd45 0 1.98e-08
X45 pd45 vr rst rg sg row4 br5_4 bs5_4 vp vn pixel ci=1e-10 ch=1e-09 rl=1000000000000.0 dark=7e-11
Cbr5_4 br5_4 0 1p
Rbr5_4 br5_4 br5_3 .1
Cbs5_4 bs5_4 0 1p
Rbs5_4 bs5_4 bs5_3 .1
Iphoto55 pd55 0 0.0
X55 pd55 vr rst rg sg row5 br5_5 bs5_5 vp vn pixel ci=1e-10 ch=1e-09 rl=1000000000000.0 dark=7e-11
Cbr5_5 br5_5 0 1p
Rbr5_5 br5_5 br5_4 .1
Cbs5_5 bs5_5 0 1p
Rbs5_5 bs5_5 bs5_4 .1
Iphoto65 pd65 0 1.98e-08
X65 pd65 vr rst rg sg row6 br5_6 bs5_6 vp vn pixel ci=1e-10 ch=1e-09 rl=1000000000000.0 dark=7e-11
Cbr5_6 br5_6 0 1p
Rbr5_6 br5_6 br5_5 .1
Cbs5_6 bs5_6 0 1p
Rbs5_6 bs5_6 bs5_5 .1
Iphoto75 pd75 0 0.0
X75 pd75 vr rst rg sg row7 br5_7 bs5_7 vp vn pixel ci=1e-10 ch=1e-09 rl=1000000000000.0 dark=7e-11
Cbr5_7 br5_7 0 1p
Rbr5_7 br5_7 br5_6 .1
Cbs5_7 bs5_7 0 1p
Rbs5_7 bs5_7 bs5_6 .1
Iphoto85 pd85 0 1.98e-08
X85 pd85 vr rst rg sg row8 br5_8 bs5_8 vp vn pixel ci=1e-10 ch=1e-09 rl=1000000000000.0 dark=7e-11
Cbr5_8 br5_8 0 1p
Rbr5_8 br5_8 br5_7 .1
Cbs5_8 bs5_8 0 1p
Rbs5_8 bs5_8 bs5_7 .1
Iphoto95 pd95 0 0.0
X95 pd95 vr rst rg sg row9 br5_9 bs5_9 vp vn pixel ci=1e-10 ch=1e-09 rl=1000000000000.0 dark=7e-11
Cbr5_9 br5_9 0 1p
Rbr5_9 br5_9 br5_8 .1
Cbs5_9 bs5_9 0 1p
Rbs5_9 bs5_9 bs5_8 .1
Vcol6 srccol6 0 PWL(0 0 0.01027 0 0.01027002 9 0.0103099 9 0.01030992 0 0.01067 0 0.01067002 9 0.0107099 9 0.01070992 0 0.01107 0 0.01107002 9 0.0111099 9 0.01110992 0 0.01147 0 0.01147002 9 0.0115099 9 0.01150992 0 0.01187 0 0.01187002 9 0.0119099 9 0.01190992 0 0.01227 0 0.01227002 9 0.0123099 9 0.01230992 0 0.01267 0 0.01267002 9 0.0127099 9 0.01270992 0 0.01307 0 0.01307002 9 0.0131099 9 0.01310992 0 0.01347 0 0.01347002 9 0.0135099 9 0.01350992 0 0.01387 0 0.01387002 9 0.0139099 9 0.01390992 0)
Rcol6 srccol6 col6 33
Xmuxbr6 br6_0 br col6 pass
Xmuxbs6 bs6_0 bs col6 pass
Iphoto6 pd6 0 0.0
X6 pd6 vr rst rg sg row0 br6_0 bs6_0 vp vn pixel ci=1e-10 ch=1e-09 rl=1000000000000.0 dark=7e-11
Cbr6_0 br6_0 0 1p
Cbs6_0 bs6_0 0 1p
Iphoto16 pd16 0 1.98e-08
X16 pd16 vr rst rg sg row1 br6_1 bs6_1 vp vn pixel ci=1e-10 ch=1e-09 rl=1000000000000.0 dark=7e-11
Cbr6_1 br6_1 0 1p
Rbr6_1 br6_1 br6_0 .1
Cbs6_1 bs6_1 0 1p
Rbs6_1 bs6_1 bs6_0 .1
Iphoto26 pd26 0 0.0
X26 pd26 vr rst rg sg row2 br6_2 bs6_2 vp vn pixel ci=1e-10 ch=1e-09 rl=1000000000000.0 dark=7e-11
Cbr6_2 br6_2 0 1p
Rbr6_2 br6_2 br6_1 .1
Cbs6_2 bs6_2 0 1p
Rbs6_2 bs6_2 bs6_1 .1
Iphoto36 pd36 0 1.98e-08
X36 pd36 vr rst rg sg row3 br6_3 bs6_3 vp vn pixel ci=1e-10 ch=1e-09 rl=1000000000000.0 dark=7e-11
Cbr6_3 br6_3 0 1p
Rbr6_3 br6_3 br6_2 .1
Cbs6_3 bs6_3 0 1p
Rbs6_3 bs6_3 bs6_2 .1
Iphoto46 pd46 0 0.0
X46 pd46 vr rst rg sg row4 br6_4 bs6_4 vp vn pixel ci=1e-10 ch=1e-09 rl=1000000000000.0 dark=7e-11
Cbr6_4 br6_4 0 1p
Rbr6_4 br6_4 br6_3 .1
Cbs6_4 bs6_4 0 1p
Rbs6_4 bs6_4 bs6_3 .1
Iphoto56 pd56 0 1.98e-08
X56 pd56 vr rst rg sg row5 br6_5 bs6_5 vp vn pixel ci=1e-10 ch=1e-09 rl=1000000000000.0 dark=7e-11
Cbr6_5 br6_5 0 1p
Rbr6_5 br6_5 br6_4 .1
Cbs6_5 bs6_5 0 1p
Rbs6_5 bs6_5 bs6_4 .1
Iphoto66 pd66 0 0.0
X66 pd66 vr rst rg sg row6 br6_6 bs6_6 vp vn pixel ci=1e-10 ch=1e-09 rl=1000000000000.0 dark=7e-11
Cbr6_6 br6_6 0 1p
Rbr6_6 br6_6 br6_5 .1
Cbs6_6 bs6_6 0 1p
Rbs6_6 bs6_6 bs6_5 .1
Iphoto76 pd76 0 1.98e-08
X76 pd76 vr rst rg sg row7 br6_7 bs6_7 vp vn pixel ci=1e-10 ch=1e-09 rl=1000000000000.0 dark=7e-11
Cbr6_7 br6_7 0 1p
Rbr6_7 br6_7 br6_6 .1
Cbs6_7 bs6_7 0 1p
Rbs6_7 bs6_7 bs6_6 .1
Iphoto86 pd86 0 0.0
X86 pd86 vr rst rg sg row8 br6_8 bs6_8 vp vn pixel ci=1e-10 ch=1e-09 rl=1000000000000.0 dark=7e-11
Cbr6_8 br6_8 0 1p
Rbr6_8 br6_8 br6_7 .1
Cbs6_8 bs6_8 0 1p
Rbs6_8 bs6_8 bs6_7 .1
Iphoto96 pd96 0 1.98e-08
X96 pd96 vr rst rg sg row9 br6_9 bs6_9 vp vn pixel ci=1e-10 ch=1e-09 rl=1000000000000.0 dark=7e-11
Cbr6_9 br6_9 0 1p
Rbr6_9 br6_9 br6_8 .1
Cbs6_9 bs6_9 0 1p
Rbs6_9 bs6_9 bs6_8 .1
Vcol7 srccol7 0 PWL(0 0 0.01031 0 0.01031002 9 0.0103499 9 0.01034992 0 0.01071 0 0.01071002 9 0.0107499 9 0.01074992 0 0.01111 0 0.01111002 9 0.0111499 9 0.01114992 0 0.01151 0 0.01151002 9 0.0115499 9 0.01154992 0 0.01191 0 0.01191002 9 0.0119499 9 0.01194992 0 0.01231 0 0.01231002 9 0.0123499 9 0.01234992 0 0.01271 0 0.01271002 9 0.0127499 9 0.01274992 0 0.01311 0 0.01311002 9 0.0131499 9 0.01314992 0 0.01351 0 0.01351002 9 0.0135499 9 0.01354992 0 0.01391 0 0.01391002 9 0.0139499 9 0.01394992 0)
Rcol7 srccol7 col7 33
Xmuxbr7 br7_0 br col7 pass
Xmuxbs7 bs7_0 bs col7 pass
Iphoto7 pd7 0 1.98e-08
X7 pd7 vr rst rg sg row0 br7_0 bs7_0 vp vn pixel ci=1e-10 ch=1e-09 rl=1000000000000.0 dark=7e-11
Cbr7_0 br7_0 0 1p
Cbs7_0 bs7_0 0 1p
Iphoto17 pd17 0 0.0
X17 pd17 vr rst rg sg row1 br7_1 bs7_1 vp vn pixel ci=1e-10 ch=1e-09 rl=1000000000000.0 dark=7e-11
Cbr7_1 br7_1 0 1p
Rbr7_1 br7_1 br7_0 .1
Cbs7_1 bs7_1 0 1p
Rbs7_1 bs7_1 bs7_0 .1
Iphoto27 pd27 0 1.98e-08
X27 pd27 vr rst rg sg row2 br7_2 bs7_2 vp vn pixel ci=1e-10 ch=1e-09 rl=1000000000000.0 dark=7e-11
Cbr7_2 br7_2 0 1p
Rbr7_2 br7_2 br7_1 .1
Cbs7_2 bs7_2 0 1p
Rbs7_2 bs7_2 bs7_1 .1
Iphoto37 pd37 0 0.0
X37 pd37 vr rst rg sg row3 br7_3 bs7_3 vp vn pixel ci=1e-10 ch=1e-09 rl=1000000000000.0 dark=7e-11
Cbr7_3 br7_3 0 1p
Rbr7_3 br7_3 br7_2 .1
Cbs7_3 bs7_3 0 1p
Rbs7_3 bs7_3 bs7_2 .1
Iphoto47 pd47 0 1.98e-08
X47 pd47 vr rst rg sg row4 br7_4 bs7_4 vp vn pixel ci=1e-10 ch=1e-09 rl=1000000000000.0 dark=7e-11
Cbr7_4 br7_4 0 1p
Rbr7_4 br7_4 br7_3 .1
Cbs7_4 bs7_4 0 1p
Rbs7_4 bs7_4 bs7_3 .1
Iphoto57 pd57 0 0.0
X57 pd57 vr rst rg sg row5 br7_5 bs7_5 vp vn pixel ci=1e-10 ch=1e-09 rl=1000000000000.0 dark=7e-11
Cbr7_5 br7_5 0 1p
Rbr7_5 br7_5 br7_4 .1
Cbs7_5 bs7_5 0 1p
Rbs7_5 bs7_5 bs7_4 .1
Iphoto67 pd67 0 1.98e-08
X67 pd67 vr rst rg sg row6 br7_6 bs7_6 vp vn pixel ci=1e-10 ch=1e-09 rl=1000000000000.0 dark=7e-11
Cbr7_6 br7_6 0 1p
Rbr7_6 br7_6 br7_5 .1
Cbs7_6 bs7_6 0 1p
Rbs7_6 bs7_6 bs7_5 .1
Iphoto77 pd77 0 0.0
X77 pd77 vr rst rg sg row7 br7_7 bs7_7 vp vn pixel ci=1e-10 ch=1e-09 rl=1000000000000.0 dark=7e-11
Cbr7_7 br7_7 0 1p
Rbr7_7 br7_7 br7_6 .1
Cbs7_7 bs7_7 0 1p
Rbs7_7 bs7_7 bs7_6 .1
Iphoto87 pd87 0 1.98e-08
X87 pd87 vr rst rg sg row8 br7_8 bs7_8 vp vn pixel ci=1e-10 ch=1e-09 rl=1000000000000.0 dark=7e-11
Cbr7_8 br7_8 0 1p
Rbr7_8 br7_8 br7_7 .1
Cbs7_8 bs7_8 0 1p
Rbs7_8 bs7_8 bs7_7 .1
Iphoto97 pd97 0 0.0
X97 pd97 vr rst rg sg row9 br7_9 bs7_9 vp vn pixel ci=1e-10 ch=1e-09 rl=1000000000000.0 dark=7e-11
Cbr7_9 br7_9 0 1p
Rbr7_9 br7_9 br7_8 .1
Cbs7_9 bs7_9 0 1p
Rbs7_9 bs7_9 bs7_8 .1
Vcol8 srccol8 0 PWL(0 0 0.01035 0 0.01035002 9 0.0103899 9 0.01038992 0 0.01075 0 0.01075002 9 0.0107899 9 0.01078992 0 0.01115 0 0.01115002 9 0.0111899 9 0.01118992 0 0.01155 0 0.01155002 9 0.0115899 9 0.01158992 0 0.01195 0 0.01195002 9 0.0119899 9 0.01198992 0 0.01235 0 0.01235002 9 0.0123899 9 0.01238992 0 0.01275 0 0.01275002 9 0.0127899 9 0.01278992 0 0.01315 0 0.01315002 9 0.0131899 9 0.01318992 0 0.01355 0 0.01355002 9 0.0135899 9 0.01358992 0 0.01395 0 0.01395002 9 0.0139899 9 0.01398992 0)
Rcol8 srccol8 col8 33
Xmuxbr8 br8_0 br col8 pass
Xmuxbs8 bs8_0 bs col8 pass
Iphoto8 pd8 0 0.0
X8 pd8 vr rst rg sg row0 br8_0 bs8_0 vp vn pixel ci=1e-10 ch=1e-09 rl=1000000000000.0 dark=7e-11
Cbr8_0 br8_0 0 1p
Cbs8_0 bs8_0 0 1p
Iphoto18 pd18 0 1.98e-08
X18 pd18 vr rst rg sg row1 br8_1 bs8_1 vp vn pixel ci=1e-10 ch=1e-09 rl=1000000000000.0 dark=7e-11
Cbr8_1 br8_1 0 1p
Rbr8_1 br8_1 br8_0 .1
Cbs8_1 bs8_1 0 1p
Rbs8_1 bs8_1 bs8_0 .1
Iphoto28 pd28 0 0.0
X28 pd28 vr rst rg sg row2 br8_2 bs8_2 vp vn pixel ci=1e-10 ch=1e-09 rl=1000000000000.0 dark=7e-11
Cbr8_2 br8_2 0 1p
Rbr8_2 br8_2 br8_1 .1
Cbs8_2 bs8_2 0 1p
Rbs8_2 bs8_2 bs8_1 .1
Iphoto38 pd38 0 1.98e-08
X38 pd38 vr rst rg sg row3 br8_3 bs8_3 vp vn pixel ci=1e-10 ch=1e-09 rl=1000000000000.0 dark=7e-11
Cbr8_3 br8_3 0 1p
Rbr8_3 br8_3 br8_2 .1
Cbs8_3 bs8_3 0 1p
Rbs8_3 bs8_3 bs8_2 .1
Iphoto48 pd48 0 0.0
X48 pd48 vr rst rg sg row4 br8_4 bs8_4 vp vn pixel ci=1e-10 ch=1e-09 rl=1000000000000.0 dark=7e-11
Cbr8_4 br8_4 0 1p
Rbr8_4 br8_4 br8_3 .1
Cbs8_4 bs8_4 0 1p
Rbs8_4 bs8_4 bs8_3 .1
Iphoto58 pd58 0 1.98e-08
X58 pd58 vr rst rg sg row5 br8_5 bs8_5 vp vn pixel ci=1e-10 ch=1e-09 rl=1000000000000.0 dark=7e-11
Cbr8_5 br8_5 0 1p
Rbr8_5 br8_5 br8_4 .1
Cbs8_5 bs8_5 0 1p
Rbs8_5 bs8_5 bs8_4 .1
Iphoto68 pd68 0 0.0
X68 pd68 vr rst rg sg row6 br8_6 bs8_6 vp vn pixel ci=1e-10 ch=1e-09 rl=1000000000000.0 dark=7e-11
Cbr8_6 br8_6 0 1p
Rbr8_6 br8_6 br8_5 .1
Cbs8_6 bs8_6 0 1p
Rbs8_6 bs8_6 bs8_5 .1
Iphoto78 pd78 0 1.98e-08
X78 pd78 vr rst rg sg row7 br8_7 bs8_7 vp vn pixel ci=1e-10 ch=1e-09 rl=1000000000000.0 dark=7e-11
Cbr8_7 br8_7 0 1p
Rbr8_7 br8_7 br8_6 .1
Cbs8_7 bs8_7 0 1p
Rbs8_7 bs8_7 bs8_6 .1
Iphoto88 pd88 0 0.0
X88 pd88 vr rst rg sg row8 br8_8 bs8_8 vp vn pixel ci=1e-10 ch=1e-09 rl=1000000000000.0 dark=7e-11
Cbr8_8 br8_8 0 1p
Rbr8_8 br8_8 br8_7 .1
Cbs8_8 bs8_8 0 1p
Rbs8_8 bs8_8 bs8_7 .1
Iphoto98 pd98 0 1.98e-08
X98 pd98 vr rst rg sg row9 br8_9 bs8_9 vp vn pixel ci=1e-10 ch=1e-09 rl=1000000000000.0 dark=7e-11
Cbr8_9 br8_9 0 1p
Rbr8_9 br8_9 br8_8 .1
Cbs8_9 bs8_9 0 1p
Rbs8_9 bs8_9 bs8_8 .1
Vcol9 srccol9 0 PWL(0 0 0.01039 0 0.01039002 9 0.0104299 9 0.01042992 0 0.01079 0 0.01079002 9 0.0108299 9 0.01082992 0 0.01119 0 0.01119002 9 0.0112299 9 0.01122992 0 0.01159 0 0.01159002 9 0.0116299 9 0.01162992 0 0.01199 0 0.01199002 9 0.0120299 9 0.01202992 0 0.01239 0 0.01239002 9 0.0124299 9 0.01242992 0 0.01279 0 0.01279002 9 0.0128299 9 0.01282992 0 0.01319 0 0.01319002 9 0.0132299 9 0.01322992 0 0.01359 0 0.01359002 9 0.0136299 9 0.01362992 0 0.01399 0 0.01399002 9 0.0140299 9 0.01402992 0)
Rcol9 srccol9 col9 33
Xmuxbr9 br9_0 br col9 pass
Xmuxbs9 bs9_0 bs col9 pass
Iphoto9 pd9 0 1.98e-08
X9 pd9 vr rst rg sg row0 br9_0 bs9_0 vp vn pixel ci=1e-10 ch=1e-09 rl=1000000000000.0 dark=7e-11
Cbr9_0 br9_0 0 1p
Cbs9_0 bs9_0 0 1p
Iphoto19 pd19 0 0.0
X19 pd19 vr rst rg sg row1 br9_1 bs9_1 vp vn pixel ci=1e-10 ch=1e-09 rl=1000000000000.0 dark=7e-11
Cbr9_1 br9_1 0 1p
Rbr9_1 br9_1 br9_0 .1
Cbs9_1 bs9_1 0 1p
Rbs9_1 bs9_1 bs9_0 .1
Iphoto29 pd29 0 1.98e-08
X29 pd29 vr rst rg sg row2 br9_2 bs9_2 vp vn pixel ci=1e-10 ch=1e-09 rl=1000000000000.0 dark=7e-11
Cbr9_2 br9_2 0 1p
Rbr9_2 br9_2 br9_1 .1
Cbs9_2 bs9_2 0 1p
Rbs9_2 bs9_2 bs9_1 .1
Iphoto39 pd39 0 0.0
X39 pd39 vr rst rg sg row3 br9_3 bs9_3 vp vn pixel ci=1e-10 ch=1e-09 rl=1000000000000.0 dark=7e-11
Cbr9_3 br9_3 0 1p
Rbr9_3 br9_3 br9_2 .1
Cbs9_3 bs9_3 0 1p
Rbs9_3 bs9_3 bs9_2 .1
Iphoto49 pd49 0 1.98e-08
X49 pd49 vr rst rg sg row4 br9_4 bs9_4 vp vn pixel ci=1e-10 ch=1e-09 rl=1000000000000.0 dark=7e-11
Cbr9_4 br9_4 0 1p
Rbr9_4 br9_4 br9_3 .1
Cbs9_4 bs9_4 0 1p
Rbs9_4 bs9_4 bs9_3 .1
Iphoto59 pd59 0 0.0
X59 pd59 vr rst rg sg row5 br9_5 bs9_5 vp vn pixel ci=1e-10 ch=1e-09 rl=1000000000000.0 dark=7e-11
Cbr9_5 br9_5 0 1p
Rbr9_5 br9_5 br9_4 .1
Cbs9_5 bs9_5 0 1p
Rbs9_5 bs9_5 bs9_4 .1
Iphoto69 pd69 0 1.98e-08
X69 pd69 vr rst rg sg row6 br9_6 bs9_6 vp vn pixel ci=1e-10 ch=1e-09 rl=1000000000000.0 dark=7e-11
Cbr9_6 br9_6 0 1p
Rbr9_6 br9_6 br9_5 .1
Cbs9_6 bs9_6 0 1p
Rbs9_6 bs9_6 bs9_5 .1
Iphoto79 pd79 0 0.0
X79 pd79 vr rst rg sg row7 br9_7 bs9_7 vp vn pixel ci=1e-10 ch=1e-09 rl=1000000000000.0 dark=7e-11
Cbr9_7 br9_7 0 1p
Rbr9_7 br9_7 br9_6 .1
Cbs9_7 bs9_7 0 1p
Rbs9_7 bs9_7 bs9_6 .1
Iphoto89 pd89 0 1.98e-08
X89 pd89 vr rst rg sg row8 br9_8 bs9_8 vp vn pixel ci=1e-10 ch=1e-09 rl=1000000000000.0 dark=7e-11
Cbr9_8 br9_8 0 1p
Rbr9_8 br9_8 br9_7 .1
Cbs9_8 bs9_8 0 1p
Rbs9_8 bs9_8 bs9_7 .1
Iphoto99 pd99 0 0.0
X99 pd99 vr rst rg sg row9 br9_9 bs9_9 vp vn pixel ci=1e-10 ch=1e-09 rl=1000000000000.0 dark=7e-11
Cbr9_9 br9_9 0 1p
Rbr9_9 br9_9 br9_8 .1
Cbs9_9 bs9_9 0 1p
Rbs9_9 bs9_9 bs9_8 .1
Rbr br vr 1G
Rbs bs vr 1G
Cbr br 0 1.5e-11
Cbs bs 0 1.5e-11
Xafe br bs nominal black high vp vn cds pga filtered adc chain
.ends bank0
.save v(adc0) v(cds0) v(pga0) v(filtered0) v(br0) v(bs0) v(xb0.pd0) v(xb0.x0.hr) v(xb0.x0.hs)
.temp 27.0
.options method=gear gmin=1e-15 reltol=2e-5 vntol=1e-7 abstol=1e-14
.tran 4.000000000000001e-06 0.01403 0 0.0003333333333333333
.end
