.title Discrete component global shutter
Xb0 adc0 cds0 pga0 filtered0 br0 bs0 bank0
* TL081 OPERATIONAL AMPLIFIER "MACROMODEL" SUBCIRCUIT
* CREATED USING PARTS RELEASE 4.01 ON 06/16/89 AT 13:08
* (REV N/A)      SUPPLY VOLTAGE: +/-15V
* CONNECTIONS:   NON-INVERTING INPUT
*                | INVERTING INPUT
*                | | POSITIVE POWER SUPPLY
*                | | | NEGATIVE POWER SUPPLY
*                | | | | OUTPUT
*                | | | | |
.SUBCKT TL081    1 2 3 4 5
*
  C1   11 12 3.498E-12
  C2    6  7 15.00E-12
  DC    5 53 DX
  DE   54  5 DX
  DLP  90 91 DX
  DLN  92 90 DX
  DP    4  3 DX
  Ehalf mid 0 3 0 .5
Eground 99 mid 4 0 .5
  Fsum0 7 99 VB 4.715meg
Fsum1 7 99 VC -5meg
Fsum2 7 99 VE 5meg
Fsum3 7 99 VLP 5meg
Fsum4 7 99 VLN -5meg
  GA    6  0 11 12 282.8E-6
  GCM   0  6 10 99 8.942E-9
  ISS   3 10 DC 195.0E-6
  HLIM 90  0 VLIM 1K
  J1   11  2 10 JX
  J2   12  1 10 JX
  R2    6  9 100.0E3
  RD1   4 11 3.536E3
  RD2   4 12 3.536E3
  RO1   8  5 150
  RO2   7 99 150
  RP    3  4 2.143E3
  RSS  10 99 1.026E6
  VB    9  0 DC 0
  VC    3 53 DC 2.200
  VE   54  4 DC 2.200
  VLIM  7  8 DC 0
  VLP  91  0 DC 25
  VLN   0 92 DC 25
.MODEL DX D(IS=800.0E-18)
.MODEL JX PJF(IS=15.00E-12 BETA=270.1E-6 VTO=-1)
.ENDS
* ALD1106PBL. Published level-1 fit, overlap in F/m; terminal parasitics below.
.model ald_n nmos(level=1 vto=.7 kp=245u gamma=.85 phi=.9 lambda=.029
+ cbd=.5p cbs=.5p cgdo=5n cgso=5n tox=30n is=10p tnom=25)
.subckt pass a b g
Mchannel a g b 0 ald_n w=20u l=10u
Rgate g 0 10T
Cpackage g 0 .6p
.ends pass

.subckt pin an ca params: idark=70p
.model s5971 D(is={idark+1e-18} n=1.2 cjo=11.73p vj=.7 m=.5 rs=5 tnom=25)
Dpin an ca s5971
.ends pin
* -*- spice -*-
* http://www.nxp.com/documents/spice_model/1N4148.prm
*
*******************************************
*
* 1N4148
*
* NXP Semiconductors
*
* High-speed diodes
*
* VRRM = 100V
* IFRM = 450 mA
* trr  = 4ns
*
* Package pinning does not match Spice model pinning.
* Package: SOD 27
*
* Package Pin 1 : Cathode
* Package Pin 2 : Anode
*
* Simulator: PSPICE
*
*******************************************
*
.SUBCKT 1N4148 1 2
*
* The resistor R1 does not reflect
* a physical device. Instead it
* improves modeling in the reverse
* mode of operation.
*
R1 1 2 5.827E+9
D1 1 2 1N4148
*
.MODEL 1N4148 D
+ IS = 4.352E-9
+ N = 1.906
+ BV = 110
+ IBV = 0.0001
+ RS = 0.6458
+ CJO = 7.048E-13
+ VJ = 0.869
+ M = 0.03
+ FC = 0.5
+ TT = 3.48E-9
.ENDS
*

.subckt pixel pd vr rst rg sg row br bs vp vn params: ci=100p ch=1n rl=1T dark=70p
Xphoto 0 pd pin idark={dark}
Cint pd 0 {ci}
Rint pd 0 10T
Xreset vr pd rst pass
Xbuf pd out vp vn out TL081
Risol out drive 100
XsampleR drive hr rg pass
XsampleS drive hs sg pass
Chr hr 0 {ch}
Chs hs 0 {ch}
Rhr hr 0 {rl}
Rhs hs 0 {rl}
XrowR hr br row pass
XrowS hs bs row pass
.ends pixel

.subckt chain br bs nominal black vhi vp vn cds pga filtered adc
Xbr br rb vp vn rb TL081
Xbs bs sb vp vn sb TL081
Xcds rb ref vhi pass
Xbypass nominal ref 0 pass
Xlinear pga mode vhi pass
Xcomp compout mode 0 pass

Rp ref plus 100k
Rb plus black 100k
Rm sb minus 100k
Rf cds minus 100k
Xdiff plus minus vp vn cds TL081
Xgain cds fb vp vn pga TL081
Xbottom bot black 0 pass
Rground fb bot 100k
Rgain1 pga tap1 1
Xgain1 tap1 fb vhi pass
Rgain2 pga tap2 100000
Xgain2 tap2 fb 0 pass
Rgain4 pga tap4 300000
Xgain4 tap4 fb 0 pass
Rgain8 pga tap8 700000
Xgain8 tap8 fb 0 pass
Rgain16 pga tap16 1500000
Xgain16 tap16 fb 0 pass

Rcomp pga knee 10k
Xdiode knee black 1N4148
Xknee knee compout vp vn compout TL081
Rfilter mode filt 10k
Cfilter filt 0 1.9999999999999998e-10
Xfilter filt filtered vp vn filtered TL081
Xdriver filtered driven vp vn driven TL081
Riso driven adc 47
Cadc adc 0 20p
Radc adc 0 10meg
.ends chain

.subckt bank0 adc cds pga filtered br bs
Vrail rail 0 5.0
Vplus vp 0 7.5
Vminus vn 0 -7.5
Vlogic high 0 9
Rvrtop rail wvr 4000.0
Rvrbot wvr 0 6000.0
Xvr wvr bufvr vp vn bufvr TL081
Risovr bufvr vr 100

Rnominaltop rail wnominal 4000.0
Rnominalbot wnominal 0 6000.0
Xnominal wnominal bufnominal vp vn bufnominal TL081
Risonominal bufnominal nominal 100

Rblacktop rail wblack 9800.0
Rblackbot wblack 0 200.0
Xblack wblack bufblack vp vn bufblack TL081
Risoblack bufblack black 100

Vrst srcrst 0 PWL(0 9 2e-05 9 2.002e-05 0)
Rrst srcrst rst 33
Vrg srcrg 0 PWL(0 0 1e-06 0 1.02e-06 9 2.5e-05 9 2.502e-05 0)
Rrg srcrg rg 33
Vsg srcsg 0 PWL(0 0 0.010017 0 0.01001702 9 0.010025 9 0.01002502 0)
Rsg srcsg sg 33
Vrow0 srcrow0 0 PWL(0 0 0.01003 0 0.01003002 9 0.0100699 9 0.01006992 0)
Rrow0 srcrow0 row0 33
Vrow1 srcrow1 0 PWL(0 0 0.01007 0 0.01007002 9 0.0101099 9 0.01010992 0)
Rrow1 srcrow1 row1 33
Vrow2 srcrow2 0 PWL(0 0 0.01011 0 0.01011002 9 0.0101499 9 0.01014992 0)
Rrow2 srcrow2 row2 33
Vrow3 srcrow3 0 PWL(0 0 0.01015 0 0.01015002 9 0.0101899 9 0.01018992 0)
Rrow3 srcrow3 row3 33
Vrow4 srcrow4 0 PWL(0 0 0.01019 0 0.01019002 9 0.0102299 9 0.01022992 0)
Rrow4 srcrow4 row4 33
Vrow5 srcrow5 0 PWL(0 0 0.01023 0 0.01023002 9 0.0102699 9 0.01026992 0)
Rrow5 srcrow5 row5 33
Vrow6 srcrow6 0 PWL(0 0 0.01027 0 0.01027002 9 0.0103099 9 0.01030992 0)
Rrow6 srcrow6 row6 33
Vrow7 srcrow7 0 PWL(0 0 0.01031 0 0.01031002 9 0.0103499 9 0.01034992 0)
Rrow7 srcrow7 row7 33
Vrow8 srcrow8 0 PWL(0 0 0.01035 0 0.01035002 9 0.0103899 9 0.01038992 0)
Rrow8 srcrow8 row8 33
Vrow9 srcrow9 0 PWL(0 0 0.01039 0 0.01039002 9 0.0104299 9 0.01042992 0)
Rrow9 srcrow9 row9 33
Vrow10 srcrow10 0 PWL(0 0 0.01043 0 0.01043002 9 0.0104699 9 0.01046992 0)
Rrow10 srcrow10 row10 33
Vrow11 srcrow11 0 PWL(0 0 0.01047 0 0.01047002 9 0.0105099 9 0.01050992 0)
Rrow11 srcrow11 row11 33
Vrow12 srcrow12 0 PWL(0 0 0.01051 0 0.01051002 9 0.0105499 9 0.01054992 0)
Rrow12 srcrow12 row12 33
Vrow13 srcrow13 0 PWL(0 0 0.01055 0 0.01055002 9 0.0105899 9 0.01058992 0)
Rrow13 srcrow13 row13 33
Vrow14 srcrow14 0 PWL(0 0 0.01059 0 0.01059002 9 0.0106299 9 0.01062992 0)
Rrow14 srcrow14 row14 33
Vrow15 srcrow15 0 PWL(0 0 0.01063 0 0.01063002 9 0.0106699 9 0.01066992 0)
Rrow15 srcrow15 row15 33
Vrow16 srcrow16 0 PWL(0 0 0.01067 0 0.01067002 9 0.0107099 9 0.01070992 0)
Rrow16 srcrow16 row16 33
Vrow17 srcrow17 0 PWL(0 0 0.01071 0 0.01071002 9 0.0107499 9 0.01074992 0)
Rrow17 srcrow17 row17 33
Vrow18 srcrow18 0 PWL(0 0 0.01075 0 0.01075002 9 0.0107899 9 0.01078992 0)
Rrow18 srcrow18 row18 33
Vrow19 srcrow19 0 PWL(0 0 0.01079 0 0.01079002 9 0.0108299 9 0.01082992 0)
Rrow19 srcrow19 row19 33
Vrow20 srcrow20 0 PWL(0 0 0.01083 0 0.01083002 9 0.0108699 9 0.01086992 0)
Rrow20 srcrow20 row20 33
Vrow21 srcrow21 0 PWL(0 0 0.01087 0 0.01087002 9 0.0109099 9 0.01090992 0)
Rrow21 srcrow21 row21 33
Vrow22 srcrow22 0 PWL(0 0 0.01091 0 0.01091002 9 0.0109499 9 0.01094992 0)
Rrow22 srcrow22 row22 33
Vrow23 srcrow23 0 PWL(0 0 0.01095 0 0.01095002 9 0.0109899 9 0.01098992 0)
Rrow23 srcrow23 row23 33
Vrow24 srcrow24 0 PWL(0 0 0.01099 0 0.01099002 9 0.0110299 9 0.01102992 0)
Rrow24 srcrow24 row24 33
Vrow25 srcrow25 0 PWL(0 0 0.01103 0 0.01103002 9 0.0110699 9 0.01106992 0)
Rrow25 srcrow25 row25 33
Vrow26 srcrow26 0 PWL(0 0 0.01107 0 0.01107002 9 0.0111099 9 0.01110992 0)
Rrow26 srcrow26 row26 33
Vrow27 srcrow27 0 PWL(0 0 0.01111 0 0.01111002 9 0.0111499 9 0.01114992 0)
Rrow27 srcrow27 row27 33
Vrow28 srcrow28 0 PWL(0 0 0.01115 0 0.01115002 9 0.0111899 9 0.01118992 0)
Rrow28 srcrow28 row28 33
Vrow29 srcrow29 0 PWL(0 0 0.01119 0 0.01119002 9 0.0112299 9 0.01122992 0)
Rrow29 srcrow29 row29 33
Vrow30 srcrow30 0 PWL(0 0 0.01123 0 0.01123002 9 0.0112699 9 0.01126992 0)
Rrow30 srcrow30 row30 33
Vrow31 srcrow31 0 PWL(0 0 0.01127 0 0.01127002 9 0.0113099 9 0.01130992 0)
Rrow31 srcrow31 row31 33
Vcol0 srccol0 0 PWL(0 0 0.01003 0 0.01003002 9 0.0100699 9 0.01006992 0 0.01007 0 0.01007002 9 0.0101099 9 0.01010992 0 0.01011 0 0.01011002 9 0.0101499 9 0.01014992 0 0.01015 0 0.01015002 9 0.0101899 9 0.01018992 0 0.01019 0 0.01019002 9 0.0102299 9 0.01022992 0 0.01023 0 0.01023002 9 0.0102699 9 0.01026992 0 0.01027 0 0.01027002 9 0.0103099 9 0.01030992 0 0.01031 0 0.01031002 9 0.0103499 9 0.01034992 0 0.01035 0 0.01035002 9 0.0103899 9 0.01038992 0 0.01039 0 0.01039002 9 0.0104299 9 0.01042992 0 0.01043 0 0.01043002 9 0.0104699 9 0.01046992 0 0.01047 0 0.01047002 9 0.0105099 9 0.01050992 0 0.01051 0 0.01051002 9 0.0105499 9 0.01054992 0 0.01055 0 0.01055002 9 0.0105899 9 0.01058992 0 0.01059 0 0.01059002 9 0.0106299 9 0.01062992 0 0.01063 0 0.01063002 9 0.0106699 9 0.01066992 0 0.01067 0 0.01067002 9 0.0107099 9 0.01070992 0 0.01071 0 0.01071002 9 0.0107499 9 0.01074992 0 0.01075 0 0.01075002 9 0.0107899 9 0.01078992 0 0.01079 0 0.01079002 9 0.0108299 9 0.01082992 0 0.01083 0 0.01083002 9 0.0108699 9 0.01086992 0 0.01087 0 0.01087002 9 0.0109099 9 0.01090992 0 0.01091 0 0.01091002 9 0.0109499 9 0.01094992 0 0.01095 0 0.01095002 9 0.0109899 9 0.01098992 0 0.01099 0 0.01099002 9 0.0110299 9 0.01102992 0 0.01103 0 0.01103002 9 0.0110699 9 0.01106992 0 0.01107 0 0.01107002 9 0.0111099 9 0.01110992 0 0.01111 0 0.01111002 9 0.0111499 9 0.01114992 0 0.01115 0 0.01115002 9 0.0111899 9 0.01118992 0 0.01119 0 0.01119002 9 0.0112299 9 0.01122992 0 0.01123 0 0.01123002 9 0.0112699 9 0.01126992 0 0.01127 0 0.01127002 9 0.0113099 9 0.01130992 0)
Rcol0 srccol0 col0 33
Xmuxbr0 br0_0 br col0 pass
Xmuxbs0 bs0_0 bs col0 pass
Iphoto0 pd0 0 0.0
X0 pd0 vr rst rg sg row0 br0_0 bs0_0 vp vn pixel ci=1e-10 ch=1e-09 rl=1000000000000.0 dark=7e-11
Cbr0_0 br0_0 0 1p
Cbs0_0 bs0_0 0 1p
Iphoto1 pd1 0 1.98e-08
X1 pd1 vr rst rg sg row1 br0_1 bs0_1 vp vn pixel ci=1e-10 ch=1e-09 rl=1000000000000.0 dark=7e-11
Cbr0_1 br0_1 0 1p
Rbr0_1 br0_1 br0_0 .1
Cbs0_1 bs0_1 0 1p
Rbs0_1 bs0_1 bs0_0 .1
Iphoto2 pd2 0 0.0
X2 pd2 vr rst rg sg row2 br0_2 bs0_2 vp vn pixel ci=1e-10 ch=1e-09 rl=1000000000000.0 dark=7e-11
Cbr0_2 br0_2 0 1p
Rbr0_2 br0_2 br0_1 .1
Cbs0_2 bs0_2 0 1p
Rbs0_2 bs0_2 bs0_1 .1
Iphoto3 pd3 0 1.98e-08
X3 pd3 vr rst rg sg row3 br0_3 bs0_3 vp vn pixel ci=1e-10 ch=1e-09 rl=1000000000000.0 dark=7e-11
Cbr0_3 br0_3 0 1p
Rbr0_3 br0_3 br0_2 .1
Cbs0_3 bs0_3 0 1p
Rbs0_3 bs0_3 bs0_2 .1
Iphoto4 pd4 0 0.0
X4 pd4 vr rst rg sg row4 br0_4 bs0_4 vp vn pixel ci=1e-10 ch=1e-09 rl=1000000000000.0 dark=7e-11
Cbr0_4 br0_4 0 1p
Rbr0_4 br0_4 br0_3 .1
Cbs0_4 bs0_4 0 1p
Rbs0_4 bs0_4 bs0_3 .1
Iphoto5 pd5 0 1.98e-08
X5 pd5 vr rst rg sg row5 br0_5 bs0_5 vp vn pixel ci=1e-10 ch=1e-09 rl=1000000000000.0 dark=7e-11
Cbr0_5 br0_5 0 1p
Rbr0_5 br0_5 br0_4 .1
Cbs0_5 bs0_5 0 1p
Rbs0_5 bs0_5 bs0_4 .1
Iphoto6 pd6 0 0.0
X6 pd6 vr rst rg sg row6 br0_6 bs0_6 vp vn pixel ci=1e-10 ch=1e-09 rl=1000000000000.0 dark=7e-11
Cbr0_6 br0_6 0 1p
Rbr0_6 br0_6 br0_5 .1
Cbs0_6 bs0_6 0 1p
Rbs0_6 bs0_6 bs0_5 .1
Iphoto7 pd7 0 1.98e-08
X7 pd7 vr rst rg sg row7 br0_7 bs0_7 vp vn pixel ci=1e-10 ch=1e-09 rl=1000000000000.0 dark=7e-11
Cbr0_7 br0_7 0 1p
Rbr0_7 br0_7 br0_6 .1
Cbs0_7 bs0_7 0 1p
Rbs0_7 bs0_7 bs0_6 .1
Iphoto8 pd8 0 0.0
X8 pd8 vr rst rg sg row8 br0_8 bs0_8 vp vn pixel ci=1e-10 ch=1e-09 rl=1000000000000.0 dark=7e-11
Cbr0_8 br0_8 0 1p
Rbr0_8 br0_8 br0_7 .1
Cbs0_8 bs0_8 0 1p
Rbs0_8 bs0_8 bs0_7 .1
Iphoto9 pd9 0 1.98e-08
X9 pd9 vr rst rg sg row9 br0_9 bs0_9 vp vn pixel ci=1e-10 ch=1e-09 rl=1000000000000.0 dark=7e-11
Cbr0_9 br0_9 0 1p
Rbr0_9 br0_9 br0_8 .1
Cbs0_9 bs0_9 0 1p
Rbs0_9 bs0_9 bs0_8 .1
Iphoto10 pd10 0 0.0
X10 pd10 vr rst rg sg row10 br0_10 bs0_10 vp vn pixel ci=1e-10 ch=1e-09 rl=1000000000000.0 dark=7e-11
Cbr0_10 br0_10 0 1p
Rbr0_10 br0_10 br0_9 .1
Cbs0_10 bs0_10 0 1p
Rbs0_10 bs0_10 bs0_9 .1
Iphoto11 pd11 0 1.98e-08
X11 pd11 vr rst rg sg row11 br0_11 bs0_11 vp vn pixel ci=1e-10 ch=1e-09 rl=1000000000000.0 dark=7e-11
Cbr0_11 br0_11 0 1p
Rbr0_11 br0_11 br0_10 .1
Cbs0_11 bs0_11 0 1p
Rbs0_11 bs0_11 bs0_10 .1
Iphoto12 pd12 0 0.0
X12 pd12 vr rst rg sg row12 br0_12 bs0_12 vp vn pixel ci=1e-10 ch=1e-09 rl=1000000000000.0 dark=7e-11
Cbr0_12 br0_12 0 1p
Rbr0_12 br0_12 br0_11 .1
Cbs0_12 bs0_12 0 1p
Rbs0_12 bs0_12 bs0_11 .1
Iphoto13 pd13 0 1.98e-08
X13 pd13 vr rst rg sg row13 br0_13 bs0_13 vp vn pixel ci=1e-10 ch=1e-09 rl=1000000000000.0 dark=7e-11
Cbr0_13 br0_13 0 1p
Rbr0_13 br0_13 br0_12 .1
Cbs0_13 bs0_13 0 1p
Rbs0_13 bs0_13 bs0_12 .1
Iphoto14 pd14 0 0.0
X14 pd14 vr rst rg sg row14 br0_14 bs0_14 vp vn pixel ci=1e-10 ch=1e-09 rl=1000000000000.0 dark=7e-11
Cbr0_14 br0_14 0 1p
Rbr0_14 br0_14 br0_13 .1
Cbs0_14 bs0_14 0 1p
Rbs0_14 bs0_14 bs0_13 .1
Iphoto15 pd15 0 1.98e-08
X15 pd15 vr rst rg sg row15 br0_15 bs0_15 vp vn pixel ci=1e-10 ch=1e-09 rl=1000000000000.0 dark=7e-11
Cbr0_15 br0_15 0 1p
Rbr0_15 br0_15 br0_14 .1
Cbs0_15 bs0_15 0 1p
Rbs0_15 bs0_15 bs0_14 .1
Iphoto16 pd16 0 0.0
X16 pd16 vr rst rg sg row16 br0_16 bs0_16 vp vn pixel ci=1e-10 ch=1e-09 rl=1000000000000.0 dark=7e-11
Cbr0_16 br0_16 0 1p
Rbr0_16 br0_16 br0_15 .1
Cbs0_16 bs0_16 0 1p
Rbs0_16 bs0_16 bs0_15 .1
Iphoto17 pd17 0 1.98e-08
X17 pd17 vr rst rg sg row17 br0_17 bs0_17 vp vn pixel ci=1e-10 ch=1e-09 rl=1000000000000.0 dark=7e-11
Cbr0_17 br0_17 0 1p
Rbr0_17 br0_17 br0_16 .1
Cbs0_17 bs0_17 0 1p
Rbs0_17 bs0_17 bs0_16 .1
Iphoto18 pd18 0 0.0
X18 pd18 vr rst rg sg row18 br0_18 bs0_18 vp vn pixel ci=1e-10 ch=1e-09 rl=1000000000000.0 dark=7e-11
Cbr0_18 br0_18 0 1p
Rbr0_18 br0_18 br0_17 .1
Cbs0_18 bs0_18 0 1p
Rbs0_18 bs0_18 bs0_17 .1
Iphoto19 pd19 0 1.98e-08
X19 pd19 vr rst rg sg row19 br0_19 bs0_19 vp vn pixel ci=1e-10 ch=1e-09 rl=1000000000000.0 dark=7e-11
Cbr0_19 br0_19 0 1p
Rbr0_19 br0_19 br0_18 .1
Cbs0_19 bs0_19 0 1p
Rbs0_19 bs0_19 bs0_18 .1
Iphoto20 pd20 0 0.0
X20 pd20 vr rst rg sg row20 br0_20 bs0_20 vp vn pixel ci=1e-10 ch=1e-09 rl=1000000000000.0 dark=7e-11
Cbr0_20 br0_20 0 1p
Rbr0_20 br0_20 br0_19 .1
Cbs0_20 bs0_20 0 1p
Rbs0_20 bs0_20 bs0_19 .1
Iphoto21 pd21 0 1.98e-08
X21 pd21 vr rst rg sg row21 br0_21 bs0_21 vp vn pixel ci=1e-10 ch=1e-09 rl=1000000000000.0 dark=7e-11
Cbr0_21 br0_21 0 1p
Rbr0_21 br0_21 br0_20 .1
Cbs0_21 bs0_21 0 1p
Rbs0_21 bs0_21 bs0_20 .1
Iphoto22 pd22 0 0.0
X22 pd22 vr rst rg sg row22 br0_22 bs0_22 vp vn pixel ci=1e-10 ch=1e-09 rl=1000000000000.0 dark=7e-11
Cbr0_22 br0_22 0 1p
Rbr0_22 br0_22 br0_21 .1
Cbs0_22 bs0_22 0 1p
Rbs0_22 bs0_22 bs0_21 .1
Iphoto23 pd23 0 1.98e-08
X23 pd23 vr rst rg sg row23 br0_23 bs0_23 vp vn pixel ci=1e-10 ch=1e-09 rl=1000000000000.0 dark=7e-11
Cbr0_23 br0_23 0 1p
Rbr0_23 br0_23 br0_22 .1
Cbs0_23 bs0_23 0 1p
Rbs0_23 bs0_23 bs0_22 .1
Iphoto24 pd24 0 0.0
X24 pd24 vr rst rg sg row24 br0_24 bs0_24 vp vn pixel ci=1e-10 ch=1e-09 rl=1000000000000.0 dark=7e-11
Cbr0_24 br0_24 0 1p
Rbr0_24 br0_24 br0_23 .1
Cbs0_24 bs0_24 0 1p
Rbs0_24 bs0_24 bs0_23 .1
Iphoto25 pd25 0 1.98e-08
X25 pd25 vr rst rg sg row25 br0_25 bs0_25 vp vn pixel ci=1e-10 ch=1e-09 rl=1000000000000.0 dark=7e-11
Cbr0_25 br0_25 0 1p
Rbr0_25 br0_25 br0_24 .1
Cbs0_25 bs0_25 0 1p
Rbs0_25 bs0_25 bs0_24 .1
Iphoto26 pd26 0 0.0
X26 pd26 vr rst rg sg row26 br0_26 bs0_26 vp vn pixel ci=1e-10 ch=1e-09 rl=1000000000000.0 dark=7e-11
Cbr0_26 br0_26 0 1p
Rbr0_26 br0_26 br0_25 .1
Cbs0_26 bs0_26 0 1p
Rbs0_26 bs0_26 bs0_25 .1
Iphoto27 pd27 0 1.98e-08
X27 pd27 vr rst rg sg row27 br0_27 bs0_27 vp vn pixel ci=1e-10 ch=1e-09 rl=1000000000000.0 dark=7e-11
Cbr0_27 br0_27 0 1p
Rbr0_27 br0_27 br0_26 .1
Cbs0_27 bs0_27 0 1p
Rbs0_27 bs0_27 bs0_26 .1
Iphoto28 pd28 0 0.0
X28 pd28 vr rst rg sg row28 br0_28 bs0_28 vp vn pixel ci=1e-10 ch=1e-09 rl=1000000000000.0 dark=7e-11
Cbr0_28 br0_28 0 1p
Rbr0_28 br0_28 br0_27 .1
Cbs0_28 bs0_28 0 1p
Rbs0_28 bs0_28 bs0_27 .1
Iphoto29 pd29 0 1.98e-08
X29 pd29 vr rst rg sg row29 br0_29 bs0_29 vp vn pixel ci=1e-10 ch=1e-09 rl=1000000000000.0 dark=7e-11
Cbr0_29 br0_29 0 1p
Rbr0_29 br0_29 br0_28 .1
Cbs0_29 bs0_29 0 1p
Rbs0_29 bs0_29 bs0_28 .1
Iphoto30 pd30 0 0.0
X30 pd30 vr rst rg sg row30 br0_30 bs0_30 vp vn pixel ci=1e-10 ch=1e-09 rl=1000000000000.0 dark=7e-11
Cbr0_30 br0_30 0 1p
Rbr0_30 br0_30 br0_29 .1
Cbs0_30 bs0_30 0 1p
Rbs0_30 bs0_30 bs0_29 .1
Iphoto31 pd31 0 1.98e-08
X31 pd31 vr rst rg sg row31 br0_31 bs0_31 vp vn pixel ci=1e-10 ch=1e-09 rl=1000000000000.0 dark=7e-11
Cbr0_31 br0_31 0 1p
Rbr0_31 br0_31 br0_30 .1
Cbs0_31 bs0_31 0 1p
Rbs0_31 bs0_31 bs0_30 .1
Rbr br vr 1G
Rbs bs vr 1G
Cbr br 0 5.9999999999999995e-12
Cbs bs 0 5.9999999999999995e-12
Xafe br bs nominal black high vp vn cds pga filtered adc chain
.ends bank0
.save v(adc0) v(cds0) v(pga0) v(filtered0) v(br0) v(bs0) v(xb0.pd0) v(xb0.x0.hr) v(xb0.x0.hs)
.temp 27.0
.options method=gear gmin=1e-15 reltol=2e-5 vntol=1e-7 abstol=1e-14
.tran 4.000000000000001e-06 0.01131 0 0.0003333333333333333
.end
