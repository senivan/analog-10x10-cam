.title Discrete component global shutter
Xb0 adc0 cds0 pga0 filtered0 br0 bs0 bank0
* TL081 OPERATIONAL AMPLIFIER "MACROMODEL" SUBCIRCUIT
* CREATED USING PARTS RELEASE 4.01 ON 06/16/89 AT 13:08
* (REV N/A)      SUPPLY VOLTAGE: +/-15V
* CONNECTIONS:   NON-INVERTING INPUT
*                | INVERTING INPUT
*                | | POSITIVE POWER SUPPLY
*                | | | NEGATIVE POWER SUPPLY
*                | | | | OUTPUT
*                | | | | |
.SUBCKT TL081    1 2 3 4 5
*
  C1   11 12 3.498E-12
  C2    6  7 15.00E-12
  DC    5 53 DX
  DE   54  5 DX
  DLP  90 91 DX
  DLN  92 90 DX
  DP    4  3 DX
  Ehalf mid 0 3 0 .5
Eground 99 mid 4 0 .5
  Fsum0 7 99 VB 4.715meg
Fsum1 7 99 VC -5meg
Fsum2 7 99 VE 5meg
Fsum3 7 99 VLP 5meg
Fsum4 7 99 VLN -5meg
  GA    6  0 11 12 282.8E-6
  GCM   0  6 10 99 8.942E-9
  ISS   3 10 DC 195.0E-6
  HLIM 90  0 VLIM 1K
  J1   11  2 10 JX
  J2   12  1 10 JX
  R2    6  9 100.0E3
  RD1   4 11 3.536E3
  RD2   4 12 3.536E3
  RO1   8  5 150
  RO2   7 99 150
  RP    3  4 2.143E3
  RSS  10 99 1.026E6
  VB    9  0 DC 0
  VC    3 53 DC 2.200
  VE   54  4 DC 2.200
  VLIM  7  8 DC 0
  VLP  91  0 DC 25
  VLN   0 92 DC 25
.MODEL DX D(IS=800.0E-18)
.MODEL JX PJF(IS=15.00E-12 BETA=270.1E-6 VTO=-1)
.ENDS
* ALD1106PBL. Published level-1 fit, overlap in F/m; terminal parasitics below.
.model ald_n nmos(level=1 vto=.7 kp=245u gamma=.85 phi=.9 lambda=.029
+ cbd=.5p cbs=.5p cgdo=5n cgso=5n tox=30n is=10p tnom=25)
.subckt pass a b g
Mchannel a g b 0 ald_n w=20u l=10u
Rgate g 0 10T
Cpackage g 0 .6p
.ends pass

.subckt pin an ca params: idark=70p
.model s5971 D(is={idark+1e-18} n=1.2 cjo=11.73p vj=.7 m=.5 rs=5 tnom=25)
Dpin an ca s5971
.ends pin
* -*- spice -*-
* http://www.nxp.com/documents/spice_model/1N4148.prm
*
*******************************************
*
* 1N4148
*
* NXP Semiconductors
*
* High-speed diodes
*
* VRRM = 100V
* IFRM = 450 mA
* trr  = 4ns
*
* Package pinning does not match Spice model pinning.
* Package: SOD 27
*
* Package Pin 1 : Cathode
* Package Pin 2 : Anode
*
* Simulator: PSPICE
*
*******************************************
*
.SUBCKT 1N4148 1 2
*
* The resistor R1 does not reflect
* a physical device. Instead it
* improves modeling in the reverse
* mode of operation.
*
R1 1 2 5.827E+9
D1 1 2 1N4148
*
.MODEL 1N4148 D
+ IS = 4.352E-9
+ N = 1.906
+ BV = 110
+ IBV = 0.0001
+ RS = 0.6458
+ CJO = 7.048E-13
+ VJ = 0.869
+ M = 0.03
+ FC = 0.5
+ TT = 3.48E-9
.ENDS
*

.subckt pixel pd vr rst rg sg row br bs vp vn params: ci=100p ch=1n rl=1T dark=70p
Xphoto 0 pd pin idark={dark}
Cint pd 0 {ci}
Rint pd 0 10T
Xreset vr pd rst pass
Xbuf pd out vp vn out TL081
Risol out drive 100
XsampleR drive hr rg pass
XsampleS drive hs sg pass
Chr hr 0 {ch}
Chs hs 0 {ch}
Rhr hr 0 {rl}
Rhs hs 0 {rl}
XrowR hr br row pass
XrowS hs bs row pass
.ends pixel

.subckt chain br bs nominal black vhi vp vn cds pga filtered adc
Xbr br rb vp vn rb TL081
Xbs bs sb vp vn sb TL081
Xcds rb ref vhi pass
Xbypass nominal ref 0 pass
Xlinear pga mode vhi pass
Xcomp compout mode 0 pass

Rp ref plus 100k
Rb plus black 100k
Rm sb minus 100k
Rf cds minus 100k
Xdiff plus minus vp vn cds TL081
Xgain cds fb vp vn pga TL081
Xbottom bot black 0 pass
Rground fb bot 100k
Rgain1 pga tap1 1
Xgain1 tap1 fb vhi pass
Rgain2 pga tap2 100000
Xgain2 tap2 fb 0 pass
Rgain4 pga tap4 300000
Xgain4 tap4 fb 0 pass
Rgain8 pga tap8 700000
Xgain8 tap8 fb 0 pass
Rgain16 pga tap16 1500000
Xgain16 tap16 fb 0 pass

Rcomp pga knee 10k
Xdiode knee black 1N4148
Xknee knee compout vp vn compout TL081
Rfilter mode filt 10k
Cfilter filt 0 1.9999999999999998e-10
Xfilter filt filtered vp vn filtered TL081
Xdriver filtered driven vp vn driven TL081
Riso driven adc 47
Cadc adc 0 20p
Radc adc 0 10meg
.ends chain

.subckt bank0 adc cds pga filtered br bs
Vrail rail 0 5.0
Vplus vp 0 7.5
Vminus vn 0 -7.5
Vlogic high 0 9
Rvrtop rail wvr 4000.0
Rvrbot wvr 0 6000.0
Xvr wvr bufvr vp vn bufvr TL081
Risovr bufvr vr 100

Rnominaltop rail wnominal 4000.0
Rnominalbot wnominal 0 6000.0
Xnominal wnominal bufnominal vp vn bufnominal TL081
Risonominal bufnominal nominal 100

Rblacktop rail wblack 9800.0
Rblackbot wblack 0 200.0
Xblack wblack bufblack vp vn bufblack TL081
Risoblack bufblack black 100

Vrst srcrst 0 PWL(0 9 2e-05 9 2.002e-05 0)
Rrst srcrst rst 33
Vrg srcrg 0 PWL(0 0 1e-06 0 1.02e-06 9 2.5e-05 9 2.502e-05 0)
Rrg srcrg rg 33
Vsg srcsg 0 PWL(0 0 0.010017 0 0.01001702 9 0.010025 9 0.01002502 0)
Rsg srcsg sg 33
Vrow0 srcrow0 0 PWL(0 0 0.01003 0 0.01003002 9 0.0113099 9 0.01130992 0)
Rrow0 srcrow0 row0 33
Vcol0 srccol0 0 PWL(0 0 0.01003 0 0.01003002 9 0.0100699 9 0.01006992 0)
Rcol0 srccol0 col0 33
Xmuxbr0 br0_0 br col0 pass
Xmuxbs0 bs0_0 bs col0 pass
Iphoto0 pd0 0 0.0
X0 pd0 vr rst rg sg row0 br0_0 bs0_0 vp vn pixel ci=1e-10 ch=1e-09 rl=1000000000000.0 dark=7e-11
Cbr0_0 br0_0 0 1p
Cbs0_0 bs0_0 0 1p
Vcol1 srccol1 0 PWL(0 0 0.01007 0 0.01007002 9 0.0101099 9 0.01010992 0)
Rcol1 srccol1 col1 33
Xmuxbr1 br1_0 br col1 pass
Xmuxbs1 bs1_0 bs col1 pass
Iphoto1 pd1 0 6.387096774193548e-10
X1 pd1 vr rst rg sg row0 br1_0 bs1_0 vp vn pixel ci=1e-10 ch=1e-09 rl=1000000000000.0 dark=7e-11
Cbr1_0 br1_0 0 1p
Cbs1_0 bs1_0 0 1p
Vcol2 srccol2 0 PWL(0 0 0.01011 0 0.01011002 9 0.0101499 9 0.01014992 0)
Rcol2 srccol2 col2 33
Xmuxbr2 br2_0 br col2 pass
Xmuxbs2 bs2_0 bs col2 pass
Iphoto2 pd2 0 1.2774193548387095e-09
X2 pd2 vr rst rg sg row0 br2_0 bs2_0 vp vn pixel ci=1e-10 ch=1e-09 rl=1000000000000.0 dark=7e-11
Cbr2_0 br2_0 0 1p
Cbs2_0 bs2_0 0 1p
Vcol3 srccol3 0 PWL(0 0 0.01015 0 0.01015002 9 0.0101899 9 0.01018992 0)
Rcol3 srccol3 col3 33
Xmuxbr3 br3_0 br col3 pass
Xmuxbs3 bs3_0 bs col3 pass
Iphoto3 pd3 0 1.9161290322580642e-09
X3 pd3 vr rst rg sg row0 br3_0 bs3_0 vp vn pixel ci=1e-10 ch=1e-09 rl=1000000000000.0 dark=7e-11
Cbr3_0 br3_0 0 1p
Cbs3_0 bs3_0 0 1p
Vcol4 srccol4 0 PWL(0 0 0.01019 0 0.01019002 9 0.0102299 9 0.01022992 0)
Rcol4 srccol4 col4 33
Xmuxbr4 br4_0 br col4 pass
Xmuxbs4 bs4_0 bs col4 pass
Iphoto4 pd4 0 2.554838709677419e-09
X4 pd4 vr rst rg sg row0 br4_0 bs4_0 vp vn pixel ci=1e-10 ch=1e-09 rl=1000000000000.0 dark=7e-11
Cbr4_0 br4_0 0 1p
Cbs4_0 bs4_0 0 1p
Vcol5 srccol5 0 PWL(0 0 0.01023 0 0.01023002 9 0.0102699 9 0.01026992 0)
Rcol5 srccol5 col5 33
Xmuxbr5 br5_0 br col5 pass
Xmuxbs5 bs5_0 bs col5 pass
Iphoto5 pd5 0 3.193548387096774e-09
X5 pd5 vr rst rg sg row0 br5_0 bs5_0 vp vn pixel ci=1e-10 ch=1e-09 rl=1000000000000.0 dark=7e-11
Cbr5_0 br5_0 0 1p
Cbs5_0 bs5_0 0 1p
Vcol6 srccol6 0 PWL(0 0 0.01027 0 0.01027002 9 0.0103099 9 0.01030992 0)
Rcol6 srccol6 col6 33
Xmuxbr6 br6_0 br col6 pass
Xmuxbs6 bs6_0 bs col6 pass
Iphoto6 pd6 0 3.8322580645161284e-09
X6 pd6 vr rst rg sg row0 br6_0 bs6_0 vp vn pixel ci=1e-10 ch=1e-09 rl=1000000000000.0 dark=7e-11
Cbr6_0 br6_0 0 1p
Cbs6_0 bs6_0 0 1p
Vcol7 srccol7 0 PWL(0 0 0.01031 0 0.01031002 9 0.0103499 9 0.01034992 0)
Rcol7 srccol7 col7 33
Xmuxbr7 br7_0 br col7 pass
Xmuxbs7 bs7_0 bs col7 pass
Iphoto7 pd7 0 4.470967741935484e-09
X7 pd7 vr rst rg sg row0 br7_0 bs7_0 vp vn pixel ci=1e-10 ch=1e-09 rl=1000000000000.0 dark=7e-11
Cbr7_0 br7_0 0 1p
Cbs7_0 bs7_0 0 1p
Vcol8 srccol8 0 PWL(0 0 0.01035 0 0.01035002 9 0.0103899 9 0.01038992 0)
Rcol8 srccol8 col8 33
Xmuxbr8 br8_0 br col8 pass
Xmuxbs8 bs8_0 bs col8 pass
Iphoto8 pd8 0 5.109677419354838e-09
X8 pd8 vr rst rg sg row0 br8_0 bs8_0 vp vn pixel ci=1e-10 ch=1e-09 rl=1000000000000.0 dark=7e-11
Cbr8_0 br8_0 0 1p
Cbs8_0 bs8_0 0 1p
Vcol9 srccol9 0 PWL(0 0 0.01039 0 0.01039002 9 0.0104299 9 0.01042992 0)
Rcol9 srccol9 col9 33
Xmuxbr9 br9_0 br col9 pass
Xmuxbs9 bs9_0 bs col9 pass
Iphoto9 pd9 0 5.748387096774194e-09
X9 pd9 vr rst rg sg row0 br9_0 bs9_0 vp vn pixel ci=1e-10 ch=1e-09 rl=1000000000000.0 dark=7e-11
Cbr9_0 br9_0 0 1p
Cbs9_0 bs9_0 0 1p
Vcol10 srccol10 0 PWL(0 0 0.01043 0 0.01043002 9 0.0104699 9 0.01046992 0)
Rcol10 srccol10 col10 33
Xmuxbr10 br10_0 br col10 pass
Xmuxbs10 bs10_0 bs col10 pass
Iphoto10 pd10 0 6.387096774193548e-09
X10 pd10 vr rst rg sg row0 br10_0 bs10_0 vp vn pixel ci=1e-10 ch=1e-09 rl=1000000000000.0 dark=7e-11
Cbr10_0 br10_0 0 1p
Cbs10_0 bs10_0 0 1p
Vcol11 srccol11 0 PWL(0 0 0.01047 0 0.01047002 9 0.0105099 9 0.01050992 0)
Rcol11 srccol11 col11 33
Xmuxbr11 br11_0 br col11 pass
Xmuxbs11 bs11_0 bs col11 pass
Iphoto11 pd11 0 7.025806451612904e-09
X11 pd11 vr rst rg sg row0 br11_0 bs11_0 vp vn pixel ci=1e-10 ch=1e-09 rl=1000000000000.0 dark=7e-11
Cbr11_0 br11_0 0 1p
Cbs11_0 bs11_0 0 1p
Vcol12 srccol12 0 PWL(0 0 0.01051 0 0.01051002 9 0.0105499 9 0.01054992 0)
Rcol12 srccol12 col12 33
Xmuxbr12 br12_0 br col12 pass
Xmuxbs12 bs12_0 bs col12 pass
Iphoto12 pd12 0 7.664516129032257e-09
X12 pd12 vr rst rg sg row0 br12_0 bs12_0 vp vn pixel ci=1e-10 ch=1e-09 rl=1000000000000.0 dark=7e-11
Cbr12_0 br12_0 0 1p
Cbs12_0 bs12_0 0 1p
Vcol13 srccol13 0 PWL(0 0 0.01055 0 0.01055002 9 0.0105899 9 0.01058992 0)
Rcol13 srccol13 col13 33
Xmuxbr13 br13_0 br col13 pass
Xmuxbs13 bs13_0 bs col13 pass
Iphoto13 pd13 0 8.303225806451614e-09
X13 pd13 vr rst rg sg row0 br13_0 bs13_0 vp vn pixel ci=1e-10 ch=1e-09 rl=1000000000000.0 dark=7e-11
Cbr13_0 br13_0 0 1p
Cbs13_0 bs13_0 0 1p
Vcol14 srccol14 0 PWL(0 0 0.01059 0 0.01059002 9 0.0106299 9 0.01062992 0)
Rcol14 srccol14 col14 33
Xmuxbr14 br14_0 br col14 pass
Xmuxbs14 bs14_0 bs col14 pass
Iphoto14 pd14 0 8.941935483870968e-09
X14 pd14 vr rst rg sg row0 br14_0 bs14_0 vp vn pixel ci=1e-10 ch=1e-09 rl=1000000000000.0 dark=7e-11
Cbr14_0 br14_0 0 1p
Cbs14_0 bs14_0 0 1p
Vcol15 srccol15 0 PWL(0 0 0.01063 0 0.01063002 9 0.0106699 9 0.01066992 0)
Rcol15 srccol15 col15 33
Xmuxbr15 br15_0 br col15 pass
Xmuxbs15 bs15_0 bs col15 pass
Iphoto15 pd15 0 9.580645161290324e-09
X15 pd15 vr rst rg sg row0 br15_0 bs15_0 vp vn pixel ci=1e-10 ch=1e-09 rl=1000000000000.0 dark=7e-11
Cbr15_0 br15_0 0 1p
Cbs15_0 bs15_0 0 1p
Vcol16 srccol16 0 PWL(0 0 0.01067 0 0.01067002 9 0.0107099 9 0.01070992 0)
Rcol16 srccol16 col16 33
Xmuxbr16 br16_0 br col16 pass
Xmuxbs16 bs16_0 bs col16 pass
Iphoto16 pd16 0 1.0219354838709676e-08
X16 pd16 vr rst rg sg row0 br16_0 bs16_0 vp vn pixel ci=1e-10 ch=1e-09 rl=1000000000000.0 dark=7e-11
Cbr16_0 br16_0 0 1p
Cbs16_0 bs16_0 0 1p
Vcol17 srccol17 0 PWL(0 0 0.01071 0 0.01071002 9 0.0107499 9 0.01074992 0)
Rcol17 srccol17 col17 33
Xmuxbr17 br17_0 br col17 pass
Xmuxbs17 bs17_0 bs col17 pass
Iphoto17 pd17 0 1.085806451612903e-08
X17 pd17 vr rst rg sg row0 br17_0 bs17_0 vp vn pixel ci=1e-10 ch=1e-09 rl=1000000000000.0 dark=7e-11
Cbr17_0 br17_0 0 1p
Cbs17_0 bs17_0 0 1p
Vcol18 srccol18 0 PWL(0 0 0.01075 0 0.01075002 9 0.0107899 9 0.01078992 0)
Rcol18 srccol18 col18 33
Xmuxbr18 br18_0 br col18 pass
Xmuxbs18 bs18_0 bs col18 pass
Iphoto18 pd18 0 1.1496774193548388e-08
X18 pd18 vr rst rg sg row0 br18_0 bs18_0 vp vn pixel ci=1e-10 ch=1e-09 rl=1000000000000.0 dark=7e-11
Cbr18_0 br18_0 0 1p
Cbs18_0 bs18_0 0 1p
Vcol19 srccol19 0 PWL(0 0 0.01079 0 0.01079002 9 0.0108299 9 0.01082992 0)
Rcol19 srccol19 col19 33
Xmuxbr19 br19_0 br col19 pass
Xmuxbs19 bs19_0 bs col19 pass
Iphoto19 pd19 0 1.2135483870967742e-08
X19 pd19 vr rst rg sg row0 br19_0 bs19_0 vp vn pixel ci=1e-10 ch=1e-09 rl=1000000000000.0 dark=7e-11
Cbr19_0 br19_0 0 1p
Cbs19_0 bs19_0 0 1p
Vcol20 srccol20 0 PWL(0 0 0.01083 0 0.01083002 9 0.0108699 9 0.01086992 0)
Rcol20 srccol20 col20 33
Xmuxbr20 br20_0 br col20 pass
Xmuxbs20 bs20_0 bs col20 pass
Iphoto20 pd20 0 1.2774193548387096e-08
X20 pd20 vr rst rg sg row0 br20_0 bs20_0 vp vn pixel ci=1e-10 ch=1e-09 rl=1000000000000.0 dark=7e-11
Cbr20_0 br20_0 0 1p
Cbs20_0 bs20_0 0 1p
Vcol21 srccol21 0 PWL(0 0 0.01087 0 0.01087002 9 0.0109099 9 0.01090992 0)
Rcol21 srccol21 col21 33
Xmuxbr21 br21_0 br col21 pass
Xmuxbs21 bs21_0 bs col21 pass
Iphoto21 pd21 0 1.3412903225806452e-08
X21 pd21 vr rst rg sg row0 br21_0 bs21_0 vp vn pixel ci=1e-10 ch=1e-09 rl=1000000000000.0 dark=7e-11
Cbr21_0 br21_0 0 1p
Cbs21_0 bs21_0 0 1p
Vcol22 srccol22 0 PWL(0 0 0.01091 0 0.01091002 9 0.0109499 9 0.01094992 0)
Rcol22 srccol22 col22 33
Xmuxbr22 br22_0 br col22 pass
Xmuxbs22 bs22_0 bs col22 pass
Iphoto22 pd22 0 1.4051612903225807e-08
X22 pd22 vr rst rg sg row0 br22_0 bs22_0 vp vn pixel ci=1e-10 ch=1e-09 rl=1000000000000.0 dark=7e-11
Cbr22_0 br22_0 0 1p
Cbs22_0 bs22_0 0 1p
Vcol23 srccol23 0 PWL(0 0 0.01095 0 0.01095002 9 0.0109899 9 0.01098992 0)
Rcol23 srccol23 col23 33
Xmuxbr23 br23_0 br col23 pass
Xmuxbs23 bs23_0 bs col23 pass
Iphoto23 pd23 0 1.4690322580645163e-08
X23 pd23 vr rst rg sg row0 br23_0 bs23_0 vp vn pixel ci=1e-10 ch=1e-09 rl=1000000000000.0 dark=7e-11
Cbr23_0 br23_0 0 1p
Cbs23_0 bs23_0 0 1p
Vcol24 srccol24 0 PWL(0 0 0.01099 0 0.01099002 9 0.0110299 9 0.01102992 0)
Rcol24 srccol24 col24 33
Xmuxbr24 br24_0 br col24 pass
Xmuxbs24 bs24_0 bs col24 pass
Iphoto24 pd24 0 1.5329032258064514e-08
X24 pd24 vr rst rg sg row0 br24_0 bs24_0 vp vn pixel ci=1e-10 ch=1e-09 rl=1000000000000.0 dark=7e-11
Cbr24_0 br24_0 0 1p
Cbs24_0 bs24_0 0 1p
Vcol25 srccol25 0 PWL(0 0 0.01103 0 0.01103002 9 0.0110699 9 0.01106992 0)
Rcol25 srccol25 col25 33
Xmuxbr25 br25_0 br col25 pass
Xmuxbs25 bs25_0 bs col25 pass
Iphoto25 pd25 0 1.596774193548387e-08
X25 pd25 vr rst rg sg row0 br25_0 bs25_0 vp vn pixel ci=1e-10 ch=1e-09 rl=1000000000000.0 dark=7e-11
Cbr25_0 br25_0 0 1p
Cbs25_0 bs25_0 0 1p
Vcol26 srccol26 0 PWL(0 0 0.01107 0 0.01107002 9 0.0111099 9 0.01110992 0)
Rcol26 srccol26 col26 33
Xmuxbr26 br26_0 br col26 pass
Xmuxbs26 bs26_0 bs col26 pass
Iphoto26 pd26 0 1.660645161290323e-08
X26 pd26 vr rst rg sg row0 br26_0 bs26_0 vp vn pixel ci=1e-10 ch=1e-09 rl=1000000000000.0 dark=7e-11
Cbr26_0 br26_0 0 1p
Cbs26_0 bs26_0 0 1p
Vcol27 srccol27 0 PWL(0 0 0.01111 0 0.01111002 9 0.0111499 9 0.01114992 0)
Rcol27 srccol27 col27 33
Xmuxbr27 br27_0 br col27 pass
Xmuxbs27 bs27_0 bs col27 pass
Iphoto27 pd27 0 1.724516129032258e-08
X27 pd27 vr rst rg sg row0 br27_0 bs27_0 vp vn pixel ci=1e-10 ch=1e-09 rl=1000000000000.0 dark=7e-11
Cbr27_0 br27_0 0 1p
Cbs27_0 bs27_0 0 1p
Vcol28 srccol28 0 PWL(0 0 0.01115 0 0.01115002 9 0.0111899 9 0.01118992 0)
Rcol28 srccol28 col28 33
Xmuxbr28 br28_0 br col28 pass
Xmuxbs28 bs28_0 bs col28 pass
Iphoto28 pd28 0 1.7883870967741936e-08
X28 pd28 vr rst rg sg row0 br28_0 bs28_0 vp vn pixel ci=1e-10 ch=1e-09 rl=1000000000000.0 dark=7e-11
Cbr28_0 br28_0 0 1p
Cbs28_0 bs28_0 0 1p
Vcol29 srccol29 0 PWL(0 0 0.01119 0 0.01119002 9 0.0112299 9 0.01122992 0)
Rcol29 srccol29 col29 33
Xmuxbr29 br29_0 br col29 pass
Xmuxbs29 bs29_0 bs col29 pass
Iphoto29 pd29 0 1.8522580645161287e-08
X29 pd29 vr rst rg sg row0 br29_0 bs29_0 vp vn pixel ci=1e-10 ch=1e-09 rl=1000000000000.0 dark=7e-11
Cbr29_0 br29_0 0 1p
Cbs29_0 bs29_0 0 1p
Vcol30 srccol30 0 PWL(0 0 0.01123 0 0.01123002 9 0.0112699 9 0.01126992 0)
Rcol30 srccol30 col30 33
Xmuxbr30 br30_0 br col30 pass
Xmuxbs30 bs30_0 bs col30 pass
Iphoto30 pd30 0 1.9161290322580648e-08
X30 pd30 vr rst rg sg row0 br30_0 bs30_0 vp vn pixel ci=1e-10 ch=1e-09 rl=1000000000000.0 dark=7e-11
Cbr30_0 br30_0 0 1p
Cbs30_0 bs30_0 0 1p
Vcol31 srccol31 0 PWL(0 0 0.01127 0 0.01127002 9 0.0113099 9 0.01130992 0)
Rcol31 srccol31 col31 33
Xmuxbr31 br31_0 br col31 pass
Xmuxbs31 bs31_0 bs col31 pass
Iphoto31 pd31 0 1.98e-08
X31 pd31 vr rst rg sg row0 br31_0 bs31_0 vp vn pixel ci=1e-10 ch=1e-09 rl=1000000000000.0 dark=7e-11
Cbr31_0 br31_0 0 1p
Cbs31_0 bs31_0 0 1p
Rbr br vr 1G
Rbs bs vr 1G
Cbr br 0 3.7e-11
Cbs bs 0 3.7e-11
Xafe br bs nominal black high vp vn cds pga filtered adc chain
.ends bank0
.save v(adc0) v(cds0) v(pga0) v(filtered0) v(br0) v(bs0) v(xb0.pd0) v(xb0.x0.hr) v(xb0.x0.hs)
.temp 27.0
.options method=gear gmin=1e-15 reltol=2e-5 vntol=1e-7 abstol=1e-14
.tran 4.000000000000001e-06 0.01131 0 0.0003333333333333333
.end
